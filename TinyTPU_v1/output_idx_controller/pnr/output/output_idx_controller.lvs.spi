$ Spice netlist generated by v2lvs
$ v2024.3_25.13    Thu Aug 1 18:56:55 PDT 2024
.INCLUDE "/courses/ee6350/pdk2023/T-N65-CM-SP-018-K3_MOM/digital/Back_End/spice/tcbn65gplus_200a/tcbn65gplus_200a.spi"
*.BUSDELIMITER <

.SUBCKT output_idx_controller clk rstn alu_init in_valid row_idx<2> row_idx<1>
+ row_idx<0> num_computation<6> num_computation<5> num_computation<4>
+ num_computation<3> num_computation<2> num_computation<1> num_computation<0>
+ m<6> m<5> m<4> m<3> m<2> m<1> m<0> k<6> k<5> k<4> k<3> k<2> k<1> k<0>
+ c_row_idx<8> c_row_idx<7> c_row_idx<6> c_row_idx<5> c_row_idx<4> c_row_idx<3>
+ c_row_idx<2> c_row_idx<1> c_row_idx<0> c_col_idx<8> c_col_idx<7> c_col_idx<6>
+ c_col_idx<5> c_col_idx<4> c_col_idx<3> c_col_idx<2> c_col_idx<1> c_col_idx<0>
+ done_flag DVDD DVSS
*.CONNECT c_row_idx<0> FE_RN_3
*.CONNECT c_row_idx<1> FE_RN_4
*.CONNECT c_row_idx<2> FE_RN_2
XFE_PHC79_c_row_idx_1 BUFFD12 $PINS I=FE_PHN78_c_row_idx_1 Z=FE_RN_4 VSS=DVSS
+ VDD=DVDD
XFE_PHC77_c_row_idx_0 BUFFD12 $PINS I=FE_PHN76_c_row_idx_0 Z=FE_RN_3 VSS=DVSS
+ VDD=DVDD
XFE_PHC75_c_row_idx_2 BUFFD12 $PINS I=FE_PHN74_c_row_idx_2 Z=FE_RN_2 VSS=DVSS
+ VDD=DVDD
XFE_PHC73_rstn DEL01 $PINS I=rstn Z=FE_PHN73_rstn VSS=DVSS VDD=DVDD
XFE_PHC72_n_5 DEL015 $PINS I=FE_PHN43_n_5 Z=FE_PHN72_n_5 VSS=DVSS VDD=DVDD
XFE_PHC71_n_6 DEL015 $PINS I=FE_PHN42_n_6 Z=FE_PHN71_n_6 VSS=DVSS VDD=DVDD
XFE_PHC70_n_181 DEL0 $PINS I=n_181 Z=FE_PHN70_n_181 VSS=DVSS VDD=DVDD
XFE_PHC69_n_171 DEL0 $PINS I=n_171 Z=FE_PHN69_n_171 VSS=DVSS VDD=DVDD
XFE_PHC68_n_168 DEL0 $PINS I=n_168 Z=FE_PHN68_n_168 VSS=DVSS VDD=DVDD
XFE_PHC67_n_167 DEL0 $PINS I=n_167 Z=FE_PHN67_n_167 VSS=DVSS VDD=DVDD
XFE_PHC66_n_176 DEL0 $PINS I=n_176 Z=FE_PHN66_n_176 VSS=DVSS VDD=DVDD
XFE_PHC65_n_160 DEL0 $PINS I=n_160 Z=FE_PHN65_n_160 VSS=DVSS VDD=DVDD
XFE_PHC64_n_170 DEL0 $PINS I=n_170 Z=FE_PHN64_n_170 VSS=DVSS VDD=DVDD
XFE_PHC63_n_190 DEL015 $PINS I=n_190 Z=FE_PHN63_n_190 VSS=DVSS VDD=DVDD
XFE_PHC62_n_179 DEL0 $PINS I=n_179 Z=FE_PHN62_n_179 VSS=DVSS VDD=DVDD
XFE_PHC61_FE_OFN3_c_col_idx_7 DEL01 $PINS I=FE_OFN3_c_col_idx_7
+ Z=FE_PHN61_FE_OFN3_c_col_idx_7 VSS=DVSS VDD=DVDD
XFE_PHC60_FE_OFN5_c_col_idx_6 DEL01 $PINS I=FE_OFN5_c_col_idx_6
+ Z=FE_PHN60_FE_OFN5_c_col_idx_6 VSS=DVSS VDD=DVDD
XFE_PHC59_FE_OFN1_c_col_idx_8 DEL01 $PINS I=FE_OFN1_c_col_idx_8
+ Z=FE_PHN59_FE_OFN1_c_col_idx_8 VSS=DVSS VDD=DVDD
XFE_PHC58_n_71 CKBD0 $PINS I=n_71 Z=FE_PHN58_n_71 VSS=DVSS VDD=DVDD
XFE_PHC57_n_107 DEL0 $PINS I=n_107 Z=FE_PHN57_n_107 VSS=DVSS VDD=DVDD
XFE_PHC56_n_145 DEL0 $PINS I=n_145 Z=FE_PHN56_n_145 VSS=DVSS VDD=DVDD
XFE_PHC55_n_157 DEL0 $PINS I=n_157 Z=FE_PHN55_n_157 VSS=DVSS VDD=DVDD
XFE_PHC54_n_189 DEL0 $PINS I=n_189 Z=FE_PHN54_n_189 VSS=DVSS VDD=DVDD
XFE_PHC53_n_186 DEL0 $PINS I=n_186 Z=FE_PHN53_n_186 VSS=DVSS VDD=DVDD
XFE_PHC52_done_flag_166 DEL0 $PINS I=done_flag_166 Z=FE_PHN52_done_flag_166
+ VSS=DVSS VDD=DVDD
XFE_PHC51_c_row_idx_1 BUFFD12 $PINS I=row_idx<1> Z=FE_PHN78_c_row_idx_1
+ VSS=DVSS VDD=DVDD
XFE_PHC50_c_row_idx_0 BUFFD12 $PINS I=row_idx<0> Z=FE_PHN76_c_row_idx_0
+ VSS=DVSS VDD=DVDD
XFE_PHC49_c_row_idx_2 BUFFD12 $PINS I=row_idx<2> Z=FE_PHN74_c_row_idx_2
+ VSS=DVSS VDD=DVDD
XFE_PHC48_n_250 DEL0 $PINS I=n_250 Z=FE_PHN48_n_250 VSS=DVSS VDD=DVDD
XFE_PHC47_c_col_os_5 DEL0 $PINS I=c_col_os<5> Z=FE_PHN47_c_col_os_5 VSS=DVSS
+ VDD=DVDD
XFE_PHC46_c_col_os_4 DEL0 $PINS I=c_col_os<4> Z=FE_PHN46_c_col_os_4 VSS=DVSS
+ VDD=DVDD
XFE_PHC45_c_col_idx_temp_4 DEL0 $PINS I=c_col_idx_temp<4>
+ Z=FE_PHN45_c_col_idx_temp_4 VSS=DVSS VDD=DVDD
XFE_PHC44_n_4 DEL0 $PINS I=n_4 Z=FE_PHN44_n_4 VSS=DVSS VDD=DVDD
XFE_PHC43_n_5 CKBD0 $PINS I=n_5 Z=FE_PHN43_n_5 VSS=DVSS VDD=DVDD
XFE_PHC42_n_6 CKBD0 $PINS I=n_6 Z=FE_PHN42_n_6 VSS=DVSS VDD=DVDD
XFE_PHC41_n_24 DEL0 $PINS I=n_24 Z=FE_PHN41_n_24 VSS=DVSS VDD=DVDD
XFE_PHC40_c_col_os_6 DEL0 $PINS I=c_col_os<6> Z=FE_PHN40_c_col_os_6 VSS=DVSS
+ VDD=DVDD
XFE_PHC39_c_col_idx_temp_5 DEL0 $PINS I=c_col_idx_temp<5>
+ Z=FE_PHN39_c_col_idx_temp_5 VSS=DVSS VDD=DVDD
XFE_PHC38_n_15 DEL0 $PINS I=n_15 Z=FE_PHN38_n_15 VSS=DVSS VDD=DVDD
XFE_PHC37_n_18 DEL0 $PINS I=n_18 Z=FE_PHN37_n_18 VSS=DVSS VDD=DVDD
XFE_PHC36_n_14 DEL0 $PINS I=n_14 Z=FE_PHN36_n_14 VSS=DVSS VDD=DVDD
XFE_PHC35_n_0 DEL0 $PINS I=n_0 Z=FE_PHN35_n_0 VSS=DVSS VDD=DVDD
XFE_PHC34_n_16 DEL0 $PINS I=n_16 Z=FE_PHN34_n_16 VSS=DVSS VDD=DVDD
XFE_PHC33_n_17 DEL015 $PINS I=n_17 Z=FE_PHN33_n_17 VSS=DVSS VDD=DVDD
XFE_PHC32_c_col_os_3 DEL0 $PINS I=c_col_os<3> Z=FE_PHN32_c_col_os_3 VSS=DVSS
+ VDD=DVDD
XFE_PHC31_n_232 DEL0 $PINS I=n_232 Z=FE_PHN31_n_232 VSS=DVSS VDD=DVDD
XFE_PHC30_n_238 DEL0 $PINS I=n_238 Z=FE_PHN30_n_238 VSS=DVSS VDD=DVDD
XFE_PHC29_c_col_idx_temp_6 DEL0 $PINS I=c_col_idx_temp<6>
+ Z=FE_PHN29_c_col_idx_temp_6 VSS=DVSS VDD=DVDD
XFE_PHC28_c_col_idx_temp_7 DEL0 $PINS I=c_col_idx_temp<7>
+ Z=FE_PHN28_c_col_idx_temp_7 VSS=DVSS VDD=DVDD
XFE_PHC27_c_col_idx_temp_3 DEL0 $PINS I=c_col_idx_temp<3>
+ Z=FE_PHN27_c_col_idx_temp_3 VSS=DVSS VDD=DVDD
XFE_PHC26_num_computated_1 DEL0 $PINS I=num_computated<1>
+ Z=FE_PHN26_num_computated_1 VSS=DVSS VDD=DVDD
XFE_PHC25_num_computated_6 DEL0 $PINS I=num_computated<6>
+ Z=FE_PHN25_num_computated_6 VSS=DVSS VDD=DVDD
XFE_PHC24_n_109 DEL0 $PINS I=n_109 Z=FE_PHN24_n_109 VSS=DVSS VDD=DVDD
XFE_PHC23_num_computated_0 DEL0 $PINS I=num_computated<0>
+ Z=FE_PHN23_num_computated_0 VSS=DVSS VDD=DVDD
XFE_PHC22_num_computated_3 DEL0 $PINS I=num_computated<3>
+ Z=FE_PHN22_num_computated_3 VSS=DVSS VDD=DVDD
XFE_PHC21_num_computated_5 DEL0 $PINS I=num_computated<5>
+ Z=FE_PHN21_num_computated_5 VSS=DVSS VDD=DVDD
XFE_PHC20_n_32 DEL0 $PINS I=n_32 Z=FE_PHN20_n_32 VSS=DVSS VDD=DVDD
XFE_PHC19_u_out_ac_i_4 DEL0 $PINS I=u_out_ac_i<4> Z=FE_PHN19_u_out_ac_i_4
+ VSS=DVSS VDD=DVDD
XFE_PHC18_u_out_ac_i_3 DEL0 $PINS I=u_out_ac_i<3> Z=FE_PHN18_u_out_ac_i_3
+ VSS=DVSS VDD=DVDD
XFE_PHC17_rstn BUFFD1 $PINS I=FE_PHN73_rstn Z=FE_PHN17_rstn VSS=DVSS VDD=DVDD
XFE_OFC16_c_col_idx_2 BUFFD12 $PINS I=FE_OFN16_c_col_idx_2 Z=c_col_idx<2>
+ VSS=DVSS VDD=DVDD
XFE_OFC15_c_col_idx_1 BUFFD12 $PINS I=FE_OFN15_c_col_idx_1 Z=c_col_idx<1>
+ VSS=DVSS VDD=DVDD
XFE_OFC14_c_col_idx_0 BUFFD12 $PINS I=FE_OFN14_c_col_idx_0 Z=c_col_idx<0>
+ VSS=DVSS VDD=DVDD
XCTS_ccl_a_inv_00002 CKND2 $PINS I=CTS_1 ZN=CTS_3 VSS=DVSS VDD=DVDD
XCTS_ccl_a_inv_00001 CKND1 $PINS I=CTS_1 ZN=CTS_2 VSS=DVSS VDD=DVDD
XCTS_cmf_inv_00050 CKND1 $PINS I=clk ZN=CTS_1 VSS=DVSS VDD=DVDD
XLTIELO_2 TIEL $PINS ZN=FE_OFN14_c_col_idx_0 VSS=DVSS VDD=DVDD
XLTIELO_1 TIEL $PINS ZN=FE_OFN15_c_col_idx_1 VSS=DVSS VDD=DVDD
XLTIELO TIEL $PINS ZN=FE_OFN16_c_col_idx_2 VSS=DVSS VDD=DVDD
XFE_OFC13_n_190 CKBD1 $PINS I=FE_PHN63_n_190 Z=FE_OFN13_n_190 VSS=DVSS VDD=DVDD
XFE_OFC12_c_col_idx_3 CKND12 $PINS I=FE_OFN12_c_col_idx_3 ZN=c_col_idx<3>
+ VSS=DVSS VDD=DVDD
XFE_OFC11_c_col_idx_3 INVD1 $PINS I=FE_OFN11_c_col_idx_3
+ ZN=FE_OFN12_c_col_idx_3 VSS=DVSS VDD=DVDD
XFE_OFC10_c_col_idx_4 CKND12 $PINS I=FE_OFN10_c_col_idx_4 ZN=c_col_idx<4>
+ VSS=DVSS VDD=DVDD
XFE_OFC9_c_col_idx_4 INVD1 $PINS I=FE_OFN9_c_col_idx_4 ZN=FE_OFN10_c_col_idx_4
+ VSS=DVSS VDD=DVDD
XFE_OFC8_c_col_idx_5 CKND12 $PINS I=FE_OFN8_c_col_idx_5 ZN=c_col_idx<5>
+ VSS=DVSS VDD=DVDD
XFE_OFC7_c_col_idx_5 INVD1 $PINS I=FE_OFN7_c_col_idx_5 ZN=FE_OFN8_c_col_idx_5
+ VSS=DVSS VDD=DVDD
XFE_OFC6_c_col_idx_6 CKND12 $PINS I=FE_OFN6_c_col_idx_6 ZN=c_col_idx<6>
+ VSS=DVSS VDD=DVDD
XFE_OFC5_c_col_idx_6 INVD1 $PINS I=FE_PHN60_FE_OFN5_c_col_idx_6
+ ZN=FE_OFN6_c_col_idx_6 VSS=DVSS VDD=DVDD
XFE_OFC4_c_col_idx_7 CKND12 $PINS I=FE_OFN4_c_col_idx_7 ZN=c_col_idx<7>
+ VSS=DVSS VDD=DVDD
XFE_OFC3_c_col_idx_7 INVD1 $PINS I=FE_PHN61_FE_OFN3_c_col_idx_7
+ ZN=FE_OFN4_c_col_idx_7 VSS=DVSS VDD=DVDD
XFE_OFC2_c_col_idx_8 CKND12 $PINS I=FE_OFN2_c_col_idx_8 ZN=c_col_idx<8>
+ VSS=DVSS VDD=DVDD
XFE_OFC1_c_col_idx_8 INVD1 $PINS I=FE_PHN59_FE_OFN1_c_col_idx_8
+ ZN=FE_OFN2_c_col_idx_8 VSS=DVSS VDD=DVDD
Xc_col_os_reg[8] EDFKCNQD1 $PINS CN=FE_PHN17_rstn CP=CTS_3 D=FE_PHN54_n_189
+ E=FE_OFN13_n_190 Q=c_col_os<8> VSS=DVSS VDD=DVDD
Xp18291A__2398 MOAI22D0 $PINS A1=n_188 A2=n_187 B1=n_188 B2=n_187 ZN=n_189
+ VSS=DVSS VDD=DVDD
Xnum_computated_reg[5] DFKCNQD1 $PINS CN=FE_PHN17_rstn CP=CTS_2 D=n_185
+ Q=num_computated<5> VSS=DVSS VDD=DVDD
Xnum_computated_reg[1] DFKCNQD1 $PINS CN=FE_PHN17_rstn CP=CTS_2 D=n_182
+ Q=num_computated<1> VSS=DVSS VDD=DVDD
Xnum_computated_reg[3] DFKCNQD1 $PINS CN=FE_PHN17_rstn CP=CTS_2 D=n_184
+ Q=num_computated<3> VSS=DVSS VDD=DVDD
Xc_col_os_reg[3] DFKCNQD1 $PINS CN=FE_PHN17_rstn CP=CTS_2 D=FE_PHN70_n_181
+ Q=c_col_os<3> VSS=DVSS VDD=DVDD
Xnum_computated_reg[0] DFKCNQD1 $PINS CN=FE_PHN17_rstn CP=CTS_2 D=n_180
+ Q=num_computated<0> VSS=DVSS VDD=DVDD
Xp18250A__5107 FA1D0 $PINS A=c_col_os<7> B=k<4> CI=n_156 CO=n_188 S=n_186
+ VSS=DVSS VDD=DVDD
Xp18246A3671__6260 IOA21D0 $PINS A1=n_183 A2=FE_PHN21_num_computated_5 B=n_163
+ ZN=n_185 VSS=DVSS VDD=DVDD
Xp18246A3670__4319 IOA21D0 $PINS A1=n_183 A2=FE_PHN22_num_computated_3 B=n_165
+ ZN=n_184 VSS=DVSS VDD=DVDD
Xp18246A3669__8428 IOA21D0 $PINS A1=n_183 A2=FE_PHN26_num_computated_1 B=n_164
+ ZN=n_182 VSS=DVSS VDD=DVDD
Xp18246A__5526 IOA21D0 $PINS A1=n_183 A2=FE_PHN32_c_col_os_3 B=n_162 ZN=n_181
+ VSS=DVSS VDD=DVDD
Xnum_computated_reg[6] EDFKCNQD1 $PINS CN=FE_PHN17_rstn CP=CTS_2 D=n_137
+ E=FE_OFN13_n_190 Q=num_computated<6> VSS=DVSS VDD=DVDD
Xc_col_os_reg[5] EDFKCNQD1 $PINS CN=FE_PHN17_rstn CP=CTS_3 D=FE_PHN56_n_145
+ E=FE_OFN13_n_190 Q=c_col_os<5> VSS=DVSS VDD=DVDD
Xc_col_os_reg[4] EDFKCNQD1 $PINS CN=FE_PHN17_rstn CP=CTS_3 D=FE_PHN57_n_107
+ E=FE_OFN13_n_190 Q=c_col_os<4> VSS=DVSS VDD=DVDD
Xp18240A__6783 MUX2ND0 $PINS I0=n_183 I1=FE_OFN13_n_190
+ S=FE_PHN23_num_computated_0 ZN=n_180 VSS=DVSS VDD=DVDD
Xp18289A3679__3680 AO22D0 $PINS A1=n_178 A2=n_121 B1=n_177 B2=c_col_idx_temp<8>
+ Z=n_179 VSS=DVSS VDD=DVDD
Xp18332A3678__1617 MOAI22D0 $PINS A1=FE_PHN64_n_170 A2=n_206 B1=n_175
+ B2=u_out_ac_i<8> ZN=n_176 VSS=DVSS VDD=DVDD
Xp18289A3680__2802 AO22D0 $PINS A1=n_178 A2=n_31 B1=n_177
+ B2=FE_PHN45_c_col_idx_temp_4 Z=n_174 VSS=DVSS VDD=DVDD
Xp18289A3681__1705 AO22D0 $PINS A1=n_178 A2=n_44 B1=n_177
+ B2=FE_PHN39_c_col_idx_temp_5 Z=n_173 VSS=DVSS VDD=DVDD
Xp18289A3682__5122 AO22D0 $PINS A1=n_178 A2=n_63 B1=n_177
+ B2=FE_PHN29_c_col_idx_temp_6 Z=n_172 VSS=DVSS VDD=DVDD
Xp18332A3683__8246 MOAI22D0 $PINS A1=FE_PHN64_n_170 A2=n_210 B1=n_175
+ B2=u_out_ac_i<5> ZN=n_171 VSS=DVSS VDD=DVDD
Xp18332A__7098 MOAI22D0 $PINS A1=FE_PHN64_n_170 A2=n_147 B1=n_175
+ B2=FE_PHN19_u_out_ac_i_4 ZN=n_169 VSS=DVSS VDD=DVDD
Xp18332A3676__6131 MOAI22D0 $PINS A1=FE_PHN64_n_170 A2=n_209 B1=n_175
+ B2=u_out_ac_i<6> ZN=n_168 VSS=DVSS VDD=DVDD
Xp18332A3677__1881 MOAI22D0 $PINS A1=FE_PHN64_n_170 A2=n_207 B1=n_175
+ B2=u_out_ac_i<7> ZN=n_167 VSS=DVSS VDD=DVDD
Xp18289A__5115 AO22D0 $PINS A1=n_178 A2=n_96 B1=n_177
+ B2=FE_PHN28_c_col_idx_temp_7 Z=n_166 VSS=DVSS VDD=DVDD
Xp18222A__7482 OAI211D0 $PINS A1=FE_PHN22_num_computated_3 A2=n_58
+ B=FE_OFN13_n_190 C=n_110 ZN=n_165 VSS=DVSS VDD=DVDD
Xp18222A3674__4733 OAI211D0 $PINS A1=FE_PHN23_num_computated_0
+ A2=FE_PHN26_num_computated_1 B=FE_OFN13_n_190 C=n_59 ZN=n_164 VSS=DVSS VDD=DVDD
Xp18222A3675__6161 OAI211D0 $PINS A1=FE_PHN21_num_computated_5 A2=n_108
+ B=FE_OFN13_n_190 C=n_136 ZN=n_163 VSS=DVSS VDD=DVDD
Xp18221A__9315 OAI211D0 $PINS A1=k<0> A2=FE_PHN32_c_col_os_3 B=FE_OFN13_n_190
+ C=n_20 ZN=n_162 VSS=DVSS VDD=DVDD
XFp18296A CKND0 $PINS I=FE_PHN64_n_170 ZN=n_161 VSS=DVSS VDD=DVDD
Xp18260A__9945 OAI31D0 $PINS A1=n_155 A2=n_158 A3=n_159 B=FE_PHN17_rstn
+ ZN=n_160 VSS=DVSS VDD=DVDD
XFp18200A CKND0 $PINS I=FE_OFN13_n_190 ZN=n_183 VSS=DVSS VDD=DVDD
Xp18227A__2883 IND3D0 $PINS A1=n_159 B1=FE_PHN17_rstn B2=n_158 ZN=n_170
+ VSS=DVSS VDD=DVDD
Xp18251A__2346 NR2D0 $PINS A1=n_154 A2=n_177 ZN=n_178 VSS=DVSS VDD=DVDD
Xp18212A__1666 FA1D0 $PINS A=FE_PHN40_c_col_os_6 B=k<3> CI=n_144 CO=n_156
+ S=n_157 VSS=DVSS VDD=DVDD
Xp17878A__7410 INR3D0 $PINS A1=n_155 B1=n_158 B2=n_159 ZN=n_190 VSS=DVSS
+ VDD=DVDD
XFp18257A CKND0 $PINS I=n_154 ZN=n_175 VSS=DVSS VDD=DVDD
Xp18258A__6417 CKND2D0 $PINS A1=n_159 A2=FE_PHN17_rstn ZN=n_154 VSS=DVSS
+ VDD=DVDD
Xp17867A__5477 OAI211D0 $PINS A1=m<6> A2=n_124 B=n_148 C=n_125 ZN=n_158
+ VSS=DVSS VDD=DVDD
Xp13248A__2398 OR2XD1 $PINS A1=n_151 A2=n_152 Z=FE_OFN1_c_col_idx_8 VSS=DVSS
+ VDD=DVDD
Xp17946A__5107 ND4D0 $PINS A1=n_143 A2=n_131 A3=n_127 A4=n_115 ZN=n_155
+ VSS=DVSS VDD=DVDD
Xp17850A__6260 OAI211D0 $PINS A1=k<0> A2=FE_PHN27_c_col_idx_temp_3 B=n_142
+ C=FE_PHN58_n_71 ZN=n_159 VSS=DVSS VDD=DVDD
Xp13239A__4319 NR2D0 $PINS A1=n_150 A2=n_149 ZN=n_152 VSS=DVSS VDD=DVDD
Xp13247A__8428 CKAN2D0 $PINS A1=n_150 A2=n_149 Z=n_151 VSS=DVSS VDD=DVDD
Xp17717A__5526 AOI221D0 $PINS A1=n_132 A2=n_133 B1=n_147 B2=m<1> C=n_134
+ ZN=n_148 VSS=DVSS VDD=DVDD
Xp13293A__6783 OR2XD1 $PINS A1=n_141 A2=n_139 Z=FE_OFN3_c_col_idx_7 VSS=DVSS
+ VDD=DVDD
Xp18170A__3680 FA1D0 $PINS A=FE_PHN47_c_col_os_5 B=k<2> CI=n_106 CO=n_144
+ S=n_145 VSS=DVSS VDD=DVDD
Xp13222A__1617 IOA21D0 $PINS A1=n_140 A2=n_40 B=n_39 ZN=n_150 VSS=DVSS VDD=DVDD
Xp17922A__2802 AOI221D0 $PINS A1=n_12 A2=n_9 B1=FE_PHN22_num_computated_3
+ B2=n_128 C=n_129 ZN=n_143 VSS=DVSS VDD=DVDD
Xp17815A__1705 AN4D0 $PINS A1=n_126 A2=n_79 A3=n_99 A4=n_83 Z=n_142 VSS=DVSS
+ VDD=DVDD
Xp13290A__5122 CKAN2D0 $PINS A1=n_140 A2=n_138 Z=n_141 VSS=DVSS VDD=DVDD
Xp13282A__8246 NR2D0 $PINS A1=n_140 A2=n_138 ZN=n_139 VSS=DVSS VDD=DVDD
Xp18366A__7098 MOAI22D0 $PINS A1=n_136 A2=FE_PHN25_num_computated_6 B1=n_136
+ B2=FE_PHN25_num_computated_6 ZN=n_137 VSS=DVSS VDD=DVDD
Xp13336A__6131 OR2XD1 $PINS A1=n_117 A2=n_119 Z=FE_OFN5_c_col_idx_6 VSS=DVSS
+ VDD=DVDD
Xp17705A__1881 OAI211D0 $PINS A1=n_133 A2=n_132 B=n_114 C=n_86 ZN=n_134
+ VSS=DVSS VDD=DVDD
Xp18007A__5115 MAOI22D0 $PINS A1=FE_PHN21_num_computated_5 A2=n_130
+ B1=FE_PHN21_num_computated_5 B2=n_130 ZN=n_131 VSS=DVSS VDD=DVDD
Xp17928A__7482 OAI211D0 $PINS A1=n_128 A2=FE_PHN22_num_computated_3 B=n_102
+ C=n_104 ZN=n_129 VSS=DVSS VDD=DVDD
Xp13197A__4733 IOA21D0 $PINS A1=n_118 A2=n_38 B=n_37 ZN=n_140 VSS=DVSS VDD=DVDD
Xp18008A__6161 MUX2ND0 $PINS I0=FE_PHN24_n_109 I1=num_computated<4> S=n_105
+ ZN=n_127 VSS=DVSS VDD=DVDD
Xp17772A__9315 AOI211D0 $PINS A1=n_81 A2=n_80 B=n_100 C=n_91 ZN=n_126 VSS=DVSS
+ VDD=DVDD
Xp17875A__9945 AOI211D0 $PINS A1=n_124 A2=m<6> B=n_208 C=n_211 ZN=n_125
+ VSS=DVSS VDD=DVDD
Xp18432A__2346 MOAI22D0 $PINS A1=n_120 A2=c_col_idx_temp<8> B1=n_120
+ B2=c_col_idx_temp<8> ZN=n_121 VSS=DVSS VDD=DVDD
Xp13327A__1666 CKAN2D0 $PINS A1=n_118 A2=n_116 Z=n_119 VSS=DVSS VDD=DVDD
Xp13336A3684__7410 NR2D0 $PINS A1=n_118 A2=n_116 ZN=n_117 VSS=DVSS VDD=DVDD
Xp17951A__6417 XNR3D0 $PINS A1=n_113 A2=num_computation<6>
+ A3=FE_PHN25_num_computated_6 ZN=n_115 VSS=DVSS VDD=DVDD
Xp17613A__5477 OA221D0 $PINS A1=n_147 A2=m<1> B1=n_67 B2=n_68 C=n_69 Z=n_114
+ VSS=DVSS VDD=DVDD
Xp18185A__2398 AOI21D0 $PINS A1=n_76 A2=num_computation<5> B=n_113 ZN=n_130
+ VSS=DVSS VDD=DVDD
Xp13383A__5107 OR2XD1 $PINS A1=n_75 A2=n_88 Z=FE_OFN7_c_col_idx_5 VSS=DVSS
+ VDD=DVDD
Xp18395A__6260 AOI21D0 $PINS A1=n_110 A2=FE_PHN24_n_109 B=n_108 ZN=n_111
+ VSS=DVSS VDD=DVDD
Xp18368A__4319 CKND2D0 $PINS A1=n_108 A2=FE_PHN21_num_computated_5 ZN=n_136
+ VSS=DVSS VDD=DVDD
Xp18107A__8428 FA1D0 $PINS A=FE_PHN46_c_col_os_4 B=k<1> CI=n_21 CO=n_106
+ S=n_107 VSS=DVSS VDD=DVDD
Xp18189A__5526 AOI21D0 $PINS A1=n_61 A2=num_computation<4> B=n_70 ZN=n_105
+ VSS=DVSS VDD=DVDD
Xp17929A__6783 MAOI22D0 $PINS A1=num_computated<2> A2=n_103
+ B1=num_computated<2> B2=n_103 ZN=n_104 VSS=DVSS VDD=DVDD
Xp17815A3685__3680 AOI221D0 $PINS A1=FE_PHN23_num_computated_0
+ A2=num_computation<0> B1=FE_PHN26_num_computated_1 B2=n_55 C=n_56 ZN=n_102
+ VSS=DVSS VDD=DVDD
Xp13185A__1617 OAI21D0 $PINS A1=n_87 A2=n_33 B=n_34 ZN=n_118 VSS=DVSS VDD=DVDD
Xp13399A__2802 OR2XD1 $PINS A1=n_254 A2=n_52 Z=FE_OFN9_c_col_idx_4 VSS=DVSS
+ VDD=DVDD
Xp17709A__1705 OAI221D0 $PINS A1=n_65 A2=n_64 B1=FE_PHN27_c_col_idx_temp_3
+ B2=n_82 C=n_66 ZN=n_100 VSS=DVSS VDD=DVDD
Xp17736A__5122 AOI221D0 $PINS A1=FE_PHN27_c_col_idx_temp_3 A2=k<0> B1=n_53
+ B2=k<6> C=n_54 ZN=n_99 VSS=DVSS VDD=DVDD
Xp18469A__7098 MOAI22D0 $PINS A1=n_95 A2=FE_PHN28_c_col_idx_temp_7 B1=n_95
+ B2=FE_PHN28_c_col_idx_temp_7 ZN=n_96 VSS=DVSS VDD=DVDD
Xp17777A__1881 MOAI22D0 $PINS A1=n_90 A2=n_89 B1=n_90 B2=n_89 ZN=n_91 VSS=DVSS
+ VDD=DVDD
Xp13375A__5115 NR2D0 $PINS A1=n_87 A2=n_41 ZN=n_88 VSS=DVSS VDD=DVDD
Xp17700A__7482 MAOI22D0 $PINS A1=n_85 A2=n_84 B1=n_85 B2=n_84 ZN=n_86 VSS=DVSS
+ VDD=DVDD
Xp17835A__4733 MAOI22D0 $PINS A1=n_82 A2=FE_PHN27_c_col_idx_temp_3 B1=n_81
+ B2=n_80 ZN=n_83 VSS=DVSS VDD=DVDD
Xp17830A__6161 MAOI22D0 $PINS A1=n_78 A2=n_77 B1=n_78 B2=n_77 ZN=n_79 VSS=DVSS
+ VDD=DVDD
Xp18118A__9315 NR2D0 $PINS A1=n_76 A2=num_computation<5> ZN=n_113 VSS=DVSS
+ VDD=DVDD
Xp18451A__9945 IND2D0 $PINS A1=n_97 B1=u_out_ac_i<7> ZN=n_122 VSS=DVSS VDD=DVDD
Xp18415A__2883 IND2D0 $PINS A1=n_95 B1=FE_PHN28_c_col_idx_temp_7 ZN=n_120
+ VSS=DVSS VDD=DVDD
Xp18339A__2346 NR2D0 $PINS A1=n_110 A2=FE_PHN24_n_109 ZN=n_108 VSS=DVSS
+ VDD=DVDD
Xp13380A__1666 NR2D0 $PINS A1=n_57 A2=n_42 ZN=n_75 VSS=DVSS VDD=DVDD
Xp18724A__5477 NR2D0 $PINS A1=FE_PHN58_n_71 A2=n_2 ZN=n_177 VSS=DVSS VDD=DVDD
XFp18114A CKND0 $PINS I=n_76 ZN=n_70 VSS=DVSS VDD=DVDD
Xp17629A__2398 CKND2D0 $PINS A1=n_68 A2=n_67 ZN=n_69 VSS=DVSS VDD=DVDD
Xp17726A__5107 CKND2D0 $PINS A1=n_65 A2=n_64 ZN=n_66 VSS=DVSS VDD=DVDD
Xp18487A__6260 MOAI22D0 $PINS A1=n_62 A2=FE_PHN29_c_col_idx_temp_6 B1=n_62
+ B2=FE_PHN29_c_col_idx_temp_6 ZN=n_63 VSS=DVSS VDD=DVDD
Xp18177A__4319 OA21D0 $PINS A1=n_50 A2=n_49 B=n_61 Z=n_128 VSS=DVSS VDD=DVDD
Xp18449A__8428 AOI21D0 $PINS A1=n_59 A2=FE_PHN20_n_32 B=n_58 ZN=n_60 VSS=DVSS
+ VDD=DVDD
XFp13166A CKND0 $PINS I=n_57 ZN=n_87 VSS=DVSS VDD=DVDD
Xp18396A__5526 IND2D0 $PINS A1=n_73 B1=u_out_ac_i<6> ZN=n_97 VSS=DVSS VDD=DVDD
Xp18365A__6783 IND2D0 $PINS A1=n_62 B1=FE_PHN29_c_col_idx_temp_6 ZN=n_95
+ VSS=DVSS VDD=DVDD
Xp18328A__3680 CKND2D0 $PINS A1=n_58 A2=FE_PHN22_num_computated_3 ZN=n_110
+ VSS=DVSS VDD=DVDD
Xp17833A__1617 NR2D0 $PINS A1=FE_PHN26_num_computated_1 A2=n_55 ZN=n_56
+ VSS=DVSS VDD=DVDD
Xp17756A__2802 NR2D0 $PINS A1=n_53 A2=k<6> ZN=n_54 VSS=DVSS VDD=DVDD
Xp13392A__1705 NR2D0 $PINS A1=n_47 A2=n_51 ZN=n_52 VSS=DVSS VDD=DVDD
Xp18162A__5122 AOI21D0 $PINS A1=n_23 A2=num_computation<2> B=n_50 ZN=n_103
+ VSS=DVSS VDD=DVDD
Xp18080A__8246 IND3D0 $PINS A1=num_computation<4> B1=n_49 B2=n_50 ZN=n_76
+ VSS=DVSS VDD=DVDD
Xp18524A3686__6131 MOAI22D0 $PINS A1=n_43 A2=FE_PHN39_c_col_idx_temp_5 B1=n_43
+ B2=FE_PHN39_c_col_idx_temp_5 ZN=n_44 VSS=DVSS VDD=DVDD
XFp13384A CKND0 $PINS I=n_41 ZN=n_42 VSS=DVSS VDD=DVDD
Xp18183A__1881 CKND2D0 $PINS A1=n_50 A2=n_49 ZN=n_61 VSS=DVSS VDD=DVDD
Xp13383A3688__5115 CKND2D0 $PINS A1=n_40 A2=n_39 ZN=n_138 VSS=DVSS VDD=DVDD
Xp18288A__7482 INR2D0 $PINS A1=FE_PHN74_c_row_idx_2 B1=n_19 ZN=n_71 VSS=DVSS
+ VDD=DVDD
Xp13388A__4733 CKND2D0 $PINS A1=n_38 A2=n_37 ZN=n_116 VSS=DVSS VDD=DVDD
Xp13168A__6161 OAI21D0 $PINS A1=n_27 A2=n_51 B=n_28 ZN=n_57 VSS=DVSS VDD=DVDD
Xp13473A__9315 AN2XD1 $PINS A1=n_255 A2=n_51 Z=FE_OFN11_c_col_idx_3 VSS=DVSS
+ VDD=DVDD
Xp17750A__9945 AOI21D0 $PINS A1=FE_PHN33_n_17 A2=k<2> B=n_64 ZN=n_90 VSS=DVSS
+ VDD=DVDD
Xp17713A__2883 AOI21D0 $PINS A1=FE_PHN38_n_15 A2=k<3> B=n_80 ZN=n_65 VSS=DVSS
+ VDD=DVDD
Xp17703A__2346 AOI21D0 $PINS A1=FE_PHN36_n_14 A2=k<1> B=n_89 ZN=n_82 VSS=DVSS
+ VDD=DVDD
Xp17778A__1666 AOI21D0 $PINS A1=FE_PHN34_n_16 A2=k<5> B=n_29 ZN=n_78 VSS=DVSS
+ VDD=DVDD
Xp17782A__7410 AOI21D0 $PINS A1=FE_PHN37_n_18 A2=k<4> B=n_77 ZN=n_81 VSS=DVSS
+ VDD=DVDD
Xp17644A__6417 AOI21D0 $PINS A1=FE_PHN43_n_5 A2=m<4> B=n_30 ZN=n_85 VSS=DVSS
+ VDD=DVDD
Xp17756A3691__5477 AO21D0 $PINS A1=FE_PHN44_n_4 A2=m<2> B=n_67 Z=n_132 VSS=DVSS
+ VDD=DVDD
Xp17609A__2398 AOI21D0 $PINS A1=FE_PHN42_n_6 A2=m<3> B=n_84 ZN=n_68 VSS=DVSS
+ VDD=DVDD
Xp17833A3689__5107 AOI21D0 $PINS A1=FE_PHN35_n_0 A2=m<5> B=n_35 ZN=n_93
+ VSS=DVSS VDD=DVDD
XFp17843A CKND0 $PINS I=n_35 ZN=n_124 VSS=DVSS VDD=DVDD
Xp13356A__6260 INR2D0 $PINS A1=n_34 B1=n_33 ZN=n_41 VSS=DVSS VDD=DVDD
Xp18299A__4319 NR2D0 $PINS A1=n_59 A2=FE_PHN20_n_32 ZN=n_58 VSS=DVSS VDD=DVDD
Xp18332A3687__8428 IND2D0 $PINS A1=n_43 B1=FE_PHN39_c_col_idx_temp_5 ZN=n_62
+ VSS=DVSS VDD=DVDD
Xp18362A__5526 IND2D0 $PINS A1=n_45 B1=u_out_ac_i<5> ZN=n_73 VSS=DVSS VDD=DVDD
Xp18532A__6783 MUX2ND0 $PINS I0=FE_PHN41_n_24 I1=FE_PHN27_c_col_idx_temp_3
+ S=FE_PHN45_c_col_idx_temp_4 ZN=n_31 VSS=DVSS VDD=DVDD
Xp18070A__3680 AOI21D0 $PINS A1=num_computation<1> A2=num_computation<0> B=n_22
+ ZN=n_55 VSS=DVSS VDD=DVDD
XFp17729A CKND0 $PINS I=n_29 ZN=n_53 VSS=DVSS VDD=DVDD
Xp13360A__1617 INR2D0 $PINS A1=n_28 B1=n_27 ZN=n_47 VSS=DVSS VDD=DVDD
Xp17648A__2802 OAI21D0 $PINS A1=c_row_idx<3> A2=c_row_idx<4> B=n_45 ZN=n_147
+ VSS=DVSS VDD=DVDD
XFp18082A CKND0 $PINS I=n_22 ZN=n_23 VSS=DVSS VDD=DVDD
XFp18131A CKND0 $PINS I=n_20 ZN=n_21 VSS=DVSS VDD=DVDD
Xp18274A__8246 ND4D0 $PINS A1=FE_PHN76_c_row_idx_0 A2=FE_PHN78_c_row_idx_1
+ A3=alu_init A4=in_valid ZN=n_19 VSS=DVSS VDD=DVDD
Xp13343A__7098 CKND2D0 $PINS A1=FE_PHN37_n_18 A2=n_7 ZN=n_40 VSS=DVSS VDD=DVDD
Xp17586A__6131 NR2D0 $PINS A1=FE_PHN42_n_6 A2=m<3> ZN=n_84 VSS=DVSS VDD=DVDD
Xp17741A__1881 NR2D0 $PINS A1=FE_PHN33_n_17 A2=k<2> ZN=n_64 VSS=DVSS VDD=DVDD
Xp18008A3690__5115 NR3D0 $PINS A1=num_computation<0> A2=num_computation<2>
+ A3=num_computation<1> ZN=n_50 VSS=DVSS VDD=DVDD
Xp18431A__7482 MOAI22D0 $PINS A1=c_col_os<8> A2=k<5> B1=c_col_os<8> B2=k<5>
+ ZN=n_187 VSS=DVSS VDD=DVDD
Xp13377A__4733 MOAI22D0 $PINS A1=c_col_idx_temp<8> A2=c_col_os<8>
+ B1=c_col_idx_temp<8> B2=c_col_os<8> ZN=n_149 VSS=DVSS VDD=DVDD
Xp17825A__6161 NR2D0 $PINS A1=FE_PHN35_n_0 A2=m<5> ZN=n_35 VSS=DVSS VDD=DVDD
Xp17734A__9315 NR2D0 $PINS A1=FE_PHN34_n_16 A2=k<5> ZN=n_29 VSS=DVSS VDD=DVDD
Xp17647A__9945 NR2D0 $PINS A1=FE_PHN43_n_5 A2=m<4> ZN=n_30 VSS=DVSS VDD=DVDD
Xp13274A__2883 CKND2D0 $PINS A1=FE_PHN38_n_15 A2=n_1 ZN=n_38 VSS=DVSS VDD=DVDD
Xp17634A__2346 NR2D0 $PINS A1=FE_PHN44_n_4 A2=m<2> ZN=n_67 VSS=DVSS VDD=DVDD
Xp17711A__1666 NR2D0 $PINS A1=FE_PHN36_n_14 A2=k<1> ZN=n_89 VSS=DVSS VDD=DVDD
Xp17790A__7410 NR2D0 $PINS A1=FE_PHN37_n_18 A2=k<4> ZN=n_77 VSS=DVSS VDD=DVDD
Xp17689A__6417 NR2D0 $PINS A1=FE_PHN38_n_15 A2=k<3> ZN=n_80 VSS=DVSS VDD=DVDD
Xp18107A3692__5477 CKND2D0 $PINS A1=FE_PHN32_c_col_os_3 A2=k<0> ZN=n_20
+ VSS=DVSS VDD=DVDD
Xp13177A__2398 CKND2D0 $PINS A1=FE_PHN46_c_col_os_4
+ A2=FE_PHN45_c_col_idx_temp_4 ZN=n_28 VSS=DVSS VDD=DVDD
Xp13166A__5107 NR2D0 $PINS A1=FE_PHN46_c_col_os_4 A2=FE_PHN45_c_col_idx_temp_4
+ ZN=n_27 VSS=DVSS VDD=DVDD
Xp18081A__6260 NR2D0 $PINS A1=num_computation<1> A2=num_computation<0> ZN=n_22
+ VSS=DVSS VDD=DVDD
Xp18319A__4319 CKND2D0 $PINS A1=FE_PHN45_c_col_idx_temp_4
+ A2=FE_PHN27_c_col_idx_temp_3 ZN=n_43 VSS=DVSS VDD=DVDD
Xp13132A__8428 CKND2D0 $PINS A1=FE_PHN32_c_col_os_3
+ A2=FE_PHN27_c_col_idx_temp_3 ZN=n_51 VSS=DVSS VDD=DVDD
Xp13216A__5526 NR2D0 $PINS A1=FE_PHN39_c_col_idx_temp_5 A2=FE_PHN47_c_col_os_5
+ ZN=n_33 VSS=DVSS VDD=DVDD
Xp17794A__6783 IND2D0 $PINS A1=m<1> B1=c_row_idx<4> ZN=n_133 VSS=DVSS VDD=DVDD
Xp13310A__3680 CKND2D0 $PINS A1=FE_PHN40_c_col_os_6
+ A2=FE_PHN29_c_col_idx_temp_6 ZN=n_37 VSS=DVSS VDD=DVDD
Xp13374A__1617 CKND2D0 $PINS A1=c_col_os<7> A2=FE_PHN28_c_col_idx_temp_7
+ ZN=n_39 VSS=DVSS VDD=DVDD
Xp13233A__2802 CKND2D0 $PINS A1=FE_PHN47_c_col_os_5
+ A2=FE_PHN39_c_col_idx_temp_5 ZN=n_34 VSS=DVSS VDD=DVDD
Xp18282A__1705 CKND2D0 $PINS A1=FE_PHN23_num_computated_0
+ A2=FE_PHN26_num_computated_1 ZN=n_59 VSS=DVSS VDD=DVDD
Xp17641A__5122 CKND2D0 $PINS A1=FE_PHN19_u_out_ac_i_4 A2=FE_PHN18_u_out_ac_i_3
+ ZN=n_45 VSS=DVSS VDD=DVDD
XFp18292A CKND0 $PINS I=FE_PHN23_num_computated_0 ZN=n_12 VSS=DVSS VDD=DVDD
XFp18018A CKND0 $PINS I=num_computation<0> ZN=n_9 VSS=DVSS VDD=DVDD
XFp18786A CKND0 $PINS I=FE_PHN17_rstn ZN=n_2 VSS=DVSS VDD=DVDD
XFp18100A CKND0 $PINS I=num_computation<3> ZN=n_49 VSS=DVSS VDD=DVDD
Xg2 CKXOR2D0 $PINS A1=n_122 A2=c_row_idx<8> Z=n_206 VSS=DVSS VDD=DVDD
Xg3724 CKXOR2D0 $PINS A1=n_97 A2=u_out_ac_i<7> Z=n_207 VSS=DVSS VDD=DVDD
Xg3725 XNR2D0 $PINS A1=n_93 A2=n_30 ZN=n_208 VSS=DVSS VDD=DVDD
Xg3726 CKXOR2D0 $PINS A1=n_73 A2=u_out_ac_i<6> Z=n_209 VSS=DVSS VDD=DVDD
Xg3727 CKXOR2D0 $PINS A1=n_45 A2=u_out_ac_i<5> Z=n_210 VSS=DVSS VDD=DVDD
Xg3728 XNR2D0 $PINS A1=c_row_idx<3> A2=m<0> ZN=n_211 VSS=DVSS VDD=DVDD
Xdrc_bufs3729 INVD12 $PINS I=FE_PHN44_n_4 ZN=c_row_idx<5> VSS=DVSS VDD=DVDD
Xdrc_bufs3735 INVD12 $PINS I=FE_PHN71_n_6 ZN=c_row_idx<6> VSS=DVSS VDD=DVDD
Xdrc_bufs3741 INVD12 $PINS I=FE_PHN72_n_5 ZN=c_row_idx<7> VSS=DVSS VDD=DVDD
Xdrc_bufs3747 CKND12 $PINS I=FE_PHN31_n_232 ZN=c_row_idx<3> VSS=DVSS VDD=DVDD
Xdrc_bufs3753 INVD12 $PINS I=FE_PHN30_n_238 ZN=c_row_idx<4> VSS=DVSS VDD=DVDD
Xdrc_bufs3759 INVD12 $PINS I=FE_PHN35_n_0 ZN=c_row_idx<8> VSS=DVSS VDD=DVDD
Xdrc_bufs3765 INVD12 $PINS I=FE_PHN48_n_250 ZN=done_flag VSS=DVSS VDD=DVDD
Xc_col_os_reg[7] EDFKCND1 $PINS CN=FE_PHN17_rstn CP=CTS_3 D=FE_PHN53_n_186
+ E=FE_OFN13_n_190 Q=c_col_os<7> QN=n_7 VSS=DVSS VDD=DVDD
Xu_out_ac_j_reg[8] DFD1 $PINS CP=CTS_3 D=FE_PHN62_n_179 Q=c_col_idx_temp<8>
+ QN=n_16 VSS=DVSS VDD=DVDD
Xu_out_ac_j_reg[3] DFXD1 $PINS CP=CTS_3 DA=n_177 DB=n_178 Q=c_col_idx_temp<3>
+ QN=n_24 SA=FE_PHN27_c_col_idx_temp_3 VSS=DVSS VDD=DVDD
Xnum_computated_reg[2] EDFKCND1 $PINS CN=FE_PHN17_rstn CP=CTS_2 D=n_60
+ E=FE_OFN13_n_190 Q=num_computated<2> QN=n_32 VSS=DVSS VDD=DVDD
Xu_out_ac_j_reg[6] DFD1 $PINS CP=CTS_3 D=n_172 Q=c_col_idx_temp<6> QN=n_15
+ VSS=DVSS VDD=DVDD
Xc_col_os_reg[6] EDFKCND1 $PINS CN=FE_PHN17_rstn CP=CTS_3 D=FE_PHN55_n_157
+ E=FE_OFN13_n_190 Q=c_col_os<6> QN=n_1 VSS=DVSS VDD=DVDD
Xu_out_ac_j_reg[5] DFD1 $PINS CP=CTS_3 D=n_173 Q=c_col_idx_temp<5> QN=n_17
+ VSS=DVSS VDD=DVDD
Xu_out_ac_j_reg[4] DFD1 $PINS CP=CTS_3 D=n_174 Q=c_col_idx_temp<4> QN=n_14
+ VSS=DVSS VDD=DVDD
Xu_out_ac_j_reg[7] DFD1 $PINS CP=CTS_3 D=n_166 Q=c_col_idx_temp<7> QN=n_18
+ VSS=DVSS VDD=DVDD
Xnum_computated_reg[4] EDFKCND1 $PINS CN=FE_PHN17_rstn CP=CTS_2 D=n_111
+ E=FE_OFN13_n_190 Q=num_computated<4> QN=n_109 VSS=DVSS VDD=DVDD
Xu_out_ac_i_reg[5] DFD1 $PINS CP=CTS_3 D=FE_PHN69_n_171 Q=u_out_ac_i<5> QN=n_4
+ VSS=DVSS VDD=DVDD
Xu_out_ac_i_reg[6] DFD1 $PINS CP=CTS_3 D=FE_PHN68_n_168 Q=u_out_ac_i<6> QN=n_6
+ VSS=DVSS VDD=DVDD
Xu_out_ac_i_reg[7] DFD1 $PINS CP=CTS_3 D=FE_PHN67_n_167 Q=u_out_ac_i<7> QN=n_5
+ VSS=DVSS VDD=DVDD
Xu_out_ac_i_reg[3] DFXD1 $PINS CP=CTS_3 DA=n_175 DB=n_161 Q=u_out_ac_i<3>
+ QN=n_232 SA=FE_PHN18_u_out_ac_i_3 VSS=DVSS VDD=DVDD
Xu_out_ac_i_reg[4] DFD1 $PINS CP=CTS_2 D=n_169 Q=u_out_ac_i<4> QN=n_238
+ VSS=DVSS VDD=DVDD
Xu_out_ac_i_reg[8] DFD1 $PINS CP=CTS_3 D=FE_PHN66_n_176 Q=u_out_ac_i<8> QN=n_0
+ VSS=DVSS VDD=DVDD
Xdone_flag_reg DFXD1 $PINS CP=CTS_2 DA=FE_PHN17_rstn DB=FE_PHN52_done_flag_166
+ Q=done_flag_166 QN=n_250 SA=FE_PHN65_n_160 VSS=DVSS VDD=DVDD
Xg3804 CKAN2D0 $PINS A1=n_51 A2=n_47 Z=n_254 VSS=DVSS VDD=DVDD
Xg3805 IND2D0 $PINS A1=FE_PHN32_c_col_os_3 B1=FE_PHN41_n_24 ZN=n_255 VSS=DVSS
+ VDD=DVDD
XFILLER_T_1_364 DCAP4 $PINS VSS=DVSS VDD=DVDD
XFILLER_T_1_363 DCAP16 $PINS VSS=DVSS VDD=DVDD
XFILLER_T_1_362 DCAP64 $PINS VSS=DVSS VDD=DVDD
XFILLER_T_1_361 DCAP64 $PINS VSS=DVSS VDD=DVDD
XFILLER_T_1_359 DCAP4 $PINS VSS=DVSS VDD=DVDD
XFILLER_T_1_358 DCAP8 $PINS VSS=DVSS VDD=DVDD
XFILLER_T_1_356 DCAP4 $PINS VSS=DVSS VDD=DVDD
XFILLER_T_1_355 DCAP8 $PINS VSS=DVSS VDD=DVDD
XFILLER_T_1_354 DCAP64 $PINS VSS=DVSS VDD=DVDD
XFILLER_T_1_353 DCAP64 $PINS VSS=DVSS VDD=DVDD
XFILLER_T_1_352 DCAP4 $PINS VSS=DVSS VDD=DVDD
XFILLER_T_1_349 DCAP16 $PINS VSS=DVSS VDD=DVDD
XFILLER_T_1_348 DCAP32 $PINS VSS=DVSS VDD=DVDD
XFILLER_T_1_347 DCAP64 $PINS VSS=DVSS VDD=DVDD
XFILLER_T_1_344 DCAP4 $PINS VSS=DVSS VDD=DVDD
XFILLER_T_1_342 DCAP8 $PINS VSS=DVSS VDD=DVDD
XFILLER_T_1_339 DCAP4 $PINS VSS=DVSS VDD=DVDD
XFILLER_T_1_336 DCAP8 $PINS VSS=DVSS VDD=DVDD
XFILLER_T_1_335 DCAP16 $PINS VSS=DVSS VDD=DVDD
XFILLER_T_1_334 DCAP32 $PINS VSS=DVSS VDD=DVDD
XFILLER_T_1_333 DCAP64 $PINS VSS=DVSS VDD=DVDD
XFILLER_T_1_325 DCAP4 $PINS VSS=DVSS VDD=DVDD
XFILLER_T_1_323 DCAP4 $PINS VSS=DVSS VDD=DVDD
XFILLER_T_1_322 DCAP32 $PINS VSS=DVSS VDD=DVDD
XFILLER_T_1_321 DCAP64 $PINS VSS=DVSS VDD=DVDD
XFILLER_T_1_319 DCAP4 $PINS VSS=DVSS VDD=DVDD
XFILLER_T_1_317 DCAP4 $PINS VSS=DVSS VDD=DVDD
XFILLER_T_1_307 DCAP4 $PINS VSS=DVSS VDD=DVDD
XFILLER_T_1_306 DCAP32 $PINS VSS=DVSS VDD=DVDD
XFILLER_T_1_302 DCAP4 $PINS VSS=DVSS VDD=DVDD
XFILLER_T_1_300 DCAP4 $PINS VSS=DVSS VDD=DVDD
XFILLER_T_1_291 DCAP4 $PINS VSS=DVSS VDD=DVDD
XFILLER_T_1_290 DCAP8 $PINS VSS=DVSS VDD=DVDD
XFILLER_T_1_288 DCAP8 $PINS VSS=DVSS VDD=DVDD
XFILLER_T_1_287 DCAP32 $PINS VSS=DVSS VDD=DVDD
XFILLER_T_1_286 DCAP64 $PINS VSS=DVSS VDD=DVDD
XFILLER_T_1_274 DCAP4 $PINS VSS=DVSS VDD=DVDD
XFILLER_T_1_266 DCAP8 $PINS VSS=DVSS VDD=DVDD
XFILLER_T_1_265 DCAP16 $PINS VSS=DVSS VDD=DVDD
XFILLER_T_1_264 DCAP64 $PINS VSS=DVSS VDD=DVDD
XFILLER_T_1_247 DCAP16 $PINS VSS=DVSS VDD=DVDD
XFILLER_T_1_246 DCAP64 $PINS VSS=DVSS VDD=DVDD
XFILLER_T_1_245 DCAP4 $PINS VSS=DVSS VDD=DVDD
XFILLER_T_1_244 DCAP4 $PINS VSS=DVSS VDD=DVDD
XFILLER_T_1_231 DCAP8 $PINS VSS=DVSS VDD=DVDD
XFILLER_T_1_230 DCAP64 $PINS VSS=DVSS VDD=DVDD
XFILLER_T_1_225 DCAP4 $PINS VSS=DVSS VDD=DVDD
XFILLER_T_1_224 DCAP8 $PINS VSS=DVSS VDD=DVDD
XFILLER_T_1_223 DCAP64 $PINS VSS=DVSS VDD=DVDD
XFILLER_T_1_220 DCAP8 $PINS VSS=DVSS VDD=DVDD
XFILLER_T_1_218 DCAP4 $PINS VSS=DVSS VDD=DVDD
XFILLER_T_1_207 DCAP8 $PINS VSS=DVSS VDD=DVDD
XFILLER_T_1_197 DCAP4 $PINS VSS=DVSS VDD=DVDD
XFILLER_T_1_195 DCAP4 $PINS VSS=DVSS VDD=DVDD
XFILLER_T_1_194 DCAP8 $PINS VSS=DVSS VDD=DVDD
XFILLER_T_1_192 DCAP4 $PINS VSS=DVSS VDD=DVDD
XFILLER_T_1_191 DCAP8 $PINS VSS=DVSS VDD=DVDD
XFILLER_T_1_190 DCAP16 $PINS VSS=DVSS VDD=DVDD
XFILLER_T_1_189 DCAP32 $PINS VSS=DVSS VDD=DVDD
XFILLER_T_1_182 DCAP4 $PINS VSS=DVSS VDD=DVDD
XFILLER_T_1_181 DCAP8 $PINS VSS=DVSS VDD=DVDD
XFILLER_T_1_180 DCAP64 $PINS VSS=DVSS VDD=DVDD
XFILLER_T_1_174 DCAP4 $PINS VSS=DVSS VDD=DVDD
XFILLER_T_1_169 DCAP4 $PINS VSS=DVSS VDD=DVDD
XFILLER_T_1_165 DCAP8 $PINS VSS=DVSS VDD=DVDD
XFILLER_T_1_164 DCAP64 $PINS VSS=DVSS VDD=DVDD
XFILLER_T_1_161 DCAP8 $PINS VSS=DVSS VDD=DVDD
XFILLER_T_1_152 DCAP4 $PINS VSS=DVSS VDD=DVDD
XFILLER_T_1_148 DCAP4 $PINS VSS=DVSS VDD=DVDD
XFILLER_T_1_147 DCAP8 $PINS VSS=DVSS VDD=DVDD
XFILLER_T_1_146 DCAP64 $PINS VSS=DVSS VDD=DVDD
XFILLER_T_1_135 DCAP4 $PINS VSS=DVSS VDD=DVDD
XFILLER_T_1_134 DCAP8 $PINS VSS=DVSS VDD=DVDD
XFILLER_T_1_133 DCAP16 $PINS VSS=DVSS VDD=DVDD
XFILLER_T_1_132 DCAP64 $PINS VSS=DVSS VDD=DVDD
XFILLER_T_1_123 DCAP8 $PINS VSS=DVSS VDD=DVDD
XFILLER_T_1_120 DCAP4 $PINS VSS=DVSS VDD=DVDD
XFILLER_T_1_118 DCAP4 $PINS VSS=DVSS VDD=DVDD
XFILLER_T_1_115 DCAP4 $PINS VSS=DVSS VDD=DVDD
XFILLER_T_1_114 DCAP32 $PINS VSS=DVSS VDD=DVDD
XFILLER_T_1_113 DCAP64 $PINS VSS=DVSS VDD=DVDD
XFILLER_T_1_95 DCAP4 $PINS VSS=DVSS VDD=DVDD
XFILLER_T_1_94 DCAP32 $PINS VSS=DVSS VDD=DVDD
XFILLER_T_1_93 DCAP64 $PINS VSS=DVSS VDD=DVDD
XFILLER_T_1_90 DCAP4 $PINS VSS=DVSS VDD=DVDD
XFILLER_T_1_78 DCAP4 $PINS VSS=DVSS VDD=DVDD
XFILLER_T_1_77 DCAP16 $PINS VSS=DVSS VDD=DVDD
XFILLER_T_1_76 DCAP64 $PINS VSS=DVSS VDD=DVDD
XFILLER_T_1_75 DCAP8 $PINS VSS=DVSS VDD=DVDD
XFILLER_T_1_73 DCAP8 $PINS VSS=DVSS VDD=DVDD
XFILLER_T_1_64 DCAP32 $PINS VSS=DVSS VDD=DVDD
XFILLER_T_1_63 DCAP64 $PINS VSS=DVSS VDD=DVDD
XFILLER_T_1_55 DCAP4 $PINS VSS=DVSS VDD=DVDD
XFILLER_T_1_53 DCAP4 $PINS VSS=DVSS VDD=DVDD
XFILLER_T_1_52 DCAP16 $PINS VSS=DVSS VDD=DVDD
XFILLER_T_1_51 DCAP32 $PINS VSS=DVSS VDD=DVDD
XFILLER_T_1_40 DCAP8 $PINS VSS=DVSS VDD=DVDD
XFILLER_T_1_39 DCAP16 $PINS VSS=DVSS VDD=DVDD
XFILLER_T_1_35 DCAP4 $PINS VSS=DVSS VDD=DVDD
XFILLER_T_1_33 DCAP8 $PINS VSS=DVSS VDD=DVDD
XFILLER_T_1_28 DCAP8 $PINS VSS=DVSS VDD=DVDD
XFILLER_T_1_26 DCAP32 $PINS VSS=DVSS VDD=DVDD
XFILLER_T_1_23 DCAP4 $PINS VSS=DVSS VDD=DVDD
XFILLER_T_1_22 DCAP8 $PINS VSS=DVSS VDD=DVDD
XFILLER_T_1_14 DCAP4 $PINS VSS=DVSS VDD=DVDD
XFILLER_T_1_13 DCAP32 $PINS VSS=DVSS VDD=DVDD
.ENDS
.GLOBAL DVDD
.GLOBAL DVSS
