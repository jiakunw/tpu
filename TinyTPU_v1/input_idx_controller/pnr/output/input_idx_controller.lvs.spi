$ Spice netlist generated by v2lvs
$ v2024.3_25.13    Thu Aug 1 18:56:55 PDT 2024
.INCLUDE "/courses/ee6350/pdk2023/T-N65-CM-SP-018-K3_MOM/digital/Back_End/spice/tcbn65gplus_200a/tcbn65gplus_200a.spi"
*.BUSDELIMITER <

.SUBCKT input_idx_controller clk rstn tpu_start num_computation<6>
+ num_computation<5> num_computation<4> num_computation<3> num_computation<2>
+ num_computation<1> num_computation<0> m<6> m<5> m<4> m<3> m<2> m<1> m<0> n<6>
+ n<5> n<4> n<3> n<2> n<1> n<0> k<6> k<5> k<4> k<3> k<2> k<1> k<0> a_row_idx<8>
+ a_row_idx<7> a_row_idx<6> a_row_idx<5> a_row_idx<4> a_row_idx<3> a_row_idx<2>
+ a_row_idx<1> a_row_idx<0> a_col_idx<8> a_col_idx<7> a_col_idx<6> a_col_idx<5>
+ a_col_idx<4> a_col_idx<3> a_col_idx<2> a_col_idx<1> a_col_idx<0> b_row_idx<8>
+ b_row_idx<7> b_row_idx<6> b_row_idx<5> b_row_idx<4> b_row_idx<3> b_row_idx<2>
+ b_row_idx<1> b_row_idx<0> b_col_idx<8> b_col_idx<7> b_col_idx<6> b_col_idx<5>
+ b_col_idx<4> b_col_idx<3> b_col_idx<2> b_col_idx<1> b_col_idx<0> alu_start
+ sram_rd_en done DVDD DVSS
*.CONNECT b_row_idx<1> FE_RN_1
XFE_PHC132_tpu_start CKBD1 $PINS I=tpu_start Z=FE_PHN132_tpu_start VSS=DVSS
+ VDD=DVDD
XFE_PHC131_rstn CKBD1 $PINS I=rstn Z=FE_PHN131_rstn VSS=DVSS VDD=DVDD
XFE_PHC130_rstn CKBD0 $PINS I=FE_PHN131_rstn Z=FE_PHN130_rstn VSS=DVSS VDD=DVDD
XFE_PHC129_tpu_start BUFFD1 $PINS I=FE_PHN132_tpu_start Z=FE_PHN129_tpu_start
+ VSS=DVSS VDD=DVDD
XFE_PHC128_n_0 DEL015 $PINS I=n<0> Z=FE_PHN128_n_0 VSS=DVSS VDD=DVDD
XFE_PHC127_n_346 DEL0 $PINS I=n_346 Z=FE_PHN127_n_346 VSS=DVSS VDD=DVDD
XFE_PHC126_n_290 DEL0 $PINS I=n_290 Z=FE_PHN126_n_290 VSS=DVSS VDD=DVDD
XFE_PHC125_n_300 DEL0 $PINS I=n_300 Z=FE_PHN125_n_300 VSS=DVSS VDD=DVDD
XFE_PHC124_n_311 DEL0 $PINS I=n_311 Z=FE_PHN124_n_311 VSS=DVSS VDD=DVDD
XFE_PHC123_n_341 DEL0 $PINS I=n_341 Z=FE_PHN123_n_341 VSS=DVSS VDD=DVDD
XFE_PHC122_n_297 DEL0 $PINS I=n_297 Z=FE_PHN122_n_297 VSS=DVSS VDD=DVDD
XFE_PHC121_n_295 DEL0 $PINS I=n_295 Z=FE_PHN121_n_295 VSS=DVSS VDD=DVDD
XFE_PHC120_n_320 DEL0 $PINS I=n_320 Z=FE_PHN120_n_320 VSS=DVSS VDD=DVDD
XFE_PHC119_n_318 DEL0 $PINS I=n_318 Z=FE_PHN119_n_318 VSS=DVSS VDD=DVDD
XFE_PHC118_n_296 DEL0 $PINS I=n_296 Z=FE_PHN118_n_296 VSS=DVSS VDD=DVDD
XFE_PHC117_n_317 DEL0 $PINS I=n_317 Z=FE_PHN117_n_317 VSS=DVSS VDD=DVDD
XFE_PHC116_n_319 DEL0 $PINS I=n_319 Z=FE_PHN116_n_319 VSS=DVSS VDD=DVDD
XFE_PHC115_n_339 DEL0 $PINS I=n_339 Z=FE_PHN115_n_339 VSS=DVSS VDD=DVDD
XFE_PHC114_n_322 DEL0 $PINS I=n_322 Z=FE_PHN114_n_322 VSS=DVSS VDD=DVDD
XFE_PHC113_n_308 DEL0 $PINS I=n_308 Z=FE_PHN113_n_308 VSS=DVSS VDD=DVDD
XFE_PHC112_n_326 DEL0 $PINS I=n_326 Z=FE_PHN112_n_326 VSS=DVSS VDD=DVDD
XFE_PHC111_n_324 DEL0 $PINS I=n_324 Z=FE_PHN111_n_324 VSS=DVSS VDD=DVDD
XFE_PHC110_n_333 DEL0 $PINS I=n_333 Z=FE_PHN110_n_333 VSS=DVSS VDD=DVDD
XFE_PHC109_n_342 DEL0 $PINS I=n_342 Z=FE_PHN109_n_342 VSS=DVSS VDD=DVDD
XFE_PHC108_n_292 DEL0 $PINS I=n_292 Z=FE_PHN108_n_292 VSS=DVSS VDD=DVDD
XFE_PHC107_n_284 DEL0 $PINS I=n_284 Z=FE_PHN107_n_284 VSS=DVSS VDD=DVDD
XFE_PHC106_n_340 DEL0 $PINS I=n_340 Z=FE_PHN106_n_340 VSS=DVSS VDD=DVDD
XFE_PHC105_FE_OFN19_b_col_idx_7 DEL01 $PINS I=FE_OFN19_b_col_idx_7
+ Z=FE_PHN105_FE_OFN19_b_col_idx_7 VSS=DVSS VDD=DVDD
XFE_PHC104_FE_OFN21_b_col_idx_6 DEL01 $PINS I=FE_OFN21_b_col_idx_6
+ Z=FE_PHN104_FE_OFN21_b_col_idx_6 VSS=DVSS VDD=DVDD
XFE_PHC103_FE_OFN17_b_col_idx_8 DEL01 $PINS I=FE_OFN17_b_col_idx_8
+ Z=FE_PHN103_FE_OFN17_b_col_idx_8 VSS=DVSS VDD=DVDD
XFE_PHC102_n_178 DEL0 $PINS I=n_178 Z=FE_PHN102_n_178 VSS=DVSS VDD=DVDD
XFE_PHC101_n_239 DEL0 $PINS I=n_239 Z=FE_PHN101_n_239 VSS=DVSS VDD=DVDD
XFE_PHC100_n_265 DEL0 $PINS I=n_265 Z=FE_PHN100_n_265 VSS=DVSS VDD=DVDD
XFE_PHC99_n_264 DEL0 $PINS I=n_264 Z=FE_PHN99_n_264 VSS=DVSS VDD=DVDD
XFE_PHC98_n_258 DEL0 $PINS I=n_258 Z=FE_PHN98_n_258 VSS=DVSS VDD=DVDD
XFE_PHC97_FE_OFN0_a_row_idx_7 DEL01 $PINS I=FE_OFN0_a_row_idx_7
+ Z=FE_PHN97_FE_OFN0_a_row_idx_7 VSS=DVSS VDD=DVDD
XFE_PHC96_FE_OFN2_a_row_idx_6 DEL01 $PINS I=FE_OFN2_a_row_idx_6
+ Z=FE_PHN96_FE_OFN2_a_row_idx_6 VSS=DVSS VDD=DVDD
XFE_PHC95_FE_OFN30_a_row_idx_8 DEL015 $PINS I=FE_OFN30_a_row_idx_8
+ Z=FE_PHN95_FE_OFN30_a_row_idx_8 VSS=DVSS VDD=DVDD
XFE_PHC94_tpu_start DEL015 $PINS I=FE_PHN129_tpu_start Z=FE_PHN94_tpu_start
+ VSS=DVSS VDD=DVDD
XFE_PHC93_n_180 DEL0 $PINS I=n_180 Z=FE_PHN93_n_180 VSS=DVSS VDD=DVDD
XFE_PHC92_n_237 DEL0 $PINS I=n_237 Z=FE_PHN92_n_237 VSS=DVSS VDD=DVDD
XFE_PHC91_n_260 DEL0 $PINS I=n_260 Z=FE_PHN91_n_260 VSS=DVSS VDD=DVDD
XFE_PHC90_n_266 DEL0 $PINS I=n_266 Z=FE_PHN90_n_266 VSS=DVSS VDD=DVDD
XFE_PHC89_n_280 DEL0 $PINS I=n_280 Z=FE_PHN89_n_280 VSS=DVSS VDD=DVDD
XFE_PHC88_b_col_idx_temp_6 DEL0 $PINS I=b_col_idx_temp<6>
+ Z=FE_PHN88_b_col_idx_temp_6 VSS=DVSS VDD=DVDD
XFE_PHC87_last_data_read DEL0 $PINS I=last_data_read Z=FE_PHN87_last_data_read
+ VSS=DVSS VDD=DVDD
XFE_PHC86_n_58 DEL0 $PINS I=n_58 Z=FE_PHN86_n_58 VSS=DVSS VDD=DVDD
XFE_PHC85_n_29 DEL0 $PINS I=n_29 Z=FE_PHN85_n_29 VSS=DVSS VDD=DVDD
XFE_PHC84_n_5 DEL015 $PINS I=n_5 Z=FE_PHN84_n_5 VSS=DVSS VDD=DVDD
XFE_PHC83_n_33 DEL0 $PINS I=n_33 Z=FE_PHN83_n_33 VSS=DVSS VDD=DVDD
XFE_PHC82_n_0 DEL0 $PINS I=n_0 Z=FE_PHN82_n_0 VSS=DVSS VDD=DVDD
XFE_PHC81_n_4 DEL0 $PINS I=n_4 Z=FE_PHN81_n_4 VSS=DVSS VDD=DVDD
XFE_PHC80_n_348 DEL0 $PINS I=n_348 Z=FE_PHN80_n_348 VSS=DVSS VDD=DVDD
XFE_PHC79_n_349 DEL0 $PINS I=n_349 Z=FE_PHN79_n_349 VSS=DVSS VDD=DVDD
XFE_PHC78_a_row_idx_temp_5 DEL0 $PINS I=a_row_idx_temp<5>
+ Z=FE_PHN78_a_row_idx_temp_5 VSS=DVSS VDD=DVDD
XFE_PHC77_a_row_idx_temp_6 DEL0 $PINS I=a_row_idx_temp<6>
+ Z=FE_PHN77_a_row_idx_temp_6 VSS=DVSS VDD=DVDD
XFE_PHC76_b_col_os_5 DEL0 $PINS I=b_col_os<5> Z=FE_PHN76_b_col_os_5 VSS=DVSS
+ VDD=DVDD
XFE_PHC75_b_col_os_4 DEL0 $PINS I=b_col_os<4> Z=FE_PHN75_b_col_os_4 VSS=DVSS
+ VDD=DVDD
XFE_PHC74_b_col_idx_temp_5 DEL0 $PINS I=b_col_idx_temp<5>
+ Z=FE_PHN74_b_col_idx_temp_5 VSS=DVSS VDD=DVDD
XFE_PHC73_a_row_os_4 DEL0 $PINS I=a_row_os<4> Z=FE_PHN73_a_row_os_4 VSS=DVSS
+ VDD=DVDD
XFE_PHC72_a_row_os_5 DEL0 $PINS I=a_row_os<5> Z=FE_PHN72_a_row_os_5 VSS=DVSS
+ VDD=DVDD
XFE_PHC71_n_89 DEL0 $PINS I=n_89 Z=FE_PHN71_n_89 VSS=DVSS VDD=DVDD
XFE_PHC70_n_6 DEL0 $PINS I=n_6 Z=FE_PHN70_n_6 VSS=DVSS VDD=DVDD
XFE_PHC69_n_90 DEL0 $PINS I=n_90 Z=FE_PHN69_n_90 VSS=DVSS VDD=DVDD
XFE_PHC68_n_11 DEL0 $PINS I=n_11 Z=FE_PHN68_n_11 VSS=DVSS VDD=DVDD
XFE_PHC67_b_col_os_6 DEL0 $PINS I=b_col_os<6> Z=FE_PHN67_b_col_os_6 VSS=DVSS
+ VDD=DVDD
XFE_PHC66_a_row_os_7 DEL0 $PINS I=a_row_os<7> Z=FE_PHN66_a_row_os_7 VSS=DVSS
+ VDD=DVDD
XFE_PHC65_n_9 DEL0 $PINS I=n_9 Z=FE_PHN65_n_9 VSS=DVSS VDD=DVDD
XFE_PHC64_n_60 DEL0 $PINS I=n_60 Z=FE_PHN64_n_60 VSS=DVSS VDD=DVDD
XFE_PHC63_n_16 DEL0 $PINS I=n_16 Z=FE_PHN63_n_16 VSS=DVSS VDD=DVDD
XFE_PHC62_b_col_idx_temp_4 DEL0 $PINS I=b_col_idx_temp<4>
+ Z=FE_PHN62_b_col_idx_temp_4 VSS=DVSS VDD=DVDD
XFE_PHC61_n_30 DEL0 $PINS I=n_30 Z=FE_PHN61_n_30 VSS=DVSS VDD=DVDD
XFE_PHC60_a_row_os_6 DEL0 $PINS I=a_row_os<6> Z=FE_PHN60_a_row_os_6 VSS=DVSS
+ VDD=DVDD
XFE_PHC59_n_10 DEL0 $PINS I=n_10 Z=FE_PHN59_n_10 VSS=DVSS VDD=DVDD
XFE_PHC58_b_col_idx_temp_7 DEL0 $PINS I=b_col_idx_temp<7>
+ Z=FE_PHN58_b_col_idx_temp_7 VSS=DVSS VDD=DVDD
XFE_PHC57_n_75 DEL0 $PINS I=n_75 Z=FE_PHN57_n_75 VSS=DVSS VDD=DVDD
XFE_PHC56_a_row_idx_temp_4 DEL0 $PINS I=a_row_idx_temp<4>
+ Z=FE_PHN56_a_row_idx_temp_4 VSS=DVSS VDD=DVDD
XFE_PHC55_n_2 DEL0 $PINS I=n_2 Z=FE_PHN55_n_2 VSS=DVSS VDD=DVDD
XFE_PHC54_a_row_os_3 DEL0 $PINS I=a_row_os<3> Z=FE_PHN54_a_row_os_3 VSS=DVSS
+ VDD=DVDD
XFE_PHC53_b_col_os_3 DEL0 $PINS I=b_col_os<3> Z=FE_PHN53_b_col_os_3 VSS=DVSS
+ VDD=DVDD
XFE_PHC52_b_col_idx_temp_3 DEL0 $PINS I=b_col_idx_temp<3>
+ Z=FE_PHN52_b_col_idx_temp_3 VSS=DVSS VDD=DVDD
XFE_PHC51_FE_OFN11_a_row_idx_1 DEL0 $PINS I=FE_OFN11_a_row_idx_1
+ Z=FE_PHN51_FE_OFN11_a_row_idx_1 VSS=DVSS VDD=DVDD
XFE_PHC50_n_7 DEL0 $PINS I=n_7 Z=FE_PHN50_n_7 VSS=DVSS VDD=DVDD
XFE_PHC49_a_row_idx_temp_3 DEL0 $PINS I=a_row_idx_temp<3>
+ Z=FE_PHN49_a_row_idx_temp_3 VSS=DVSS VDD=DVDD
XFE_PHC48_u_ac_i_3 DEL0 $PINS I=u_ac_i<3> Z=FE_PHN48_u_ac_i_3 VSS=DVSS VDD=DVDD
XFE_PHC47_FE_OFN14_a_row_idx_0 DEL0 $PINS I=FE_OFN14_a_row_idx_0
+ Z=FE_PHN47_FE_OFN14_a_row_idx_0 VSS=DVSS VDD=DVDD
XFE_PHC46_FE_OFN8_a_row_idx_2 DEL0 $PINS I=FE_OFN8_a_row_idx_2
+ Z=FE_PHN46_FE_OFN8_a_row_idx_2 VSS=DVSS VDD=DVDD
XFE_PHC45_num_computated_3 DEL0 $PINS I=num_computated<3>
+ Z=FE_PHN45_num_computated_3 VSS=DVSS VDD=DVDD
XFE_PHC44_num_computated_0 DEL0 $PINS I=num_computated<0>
+ Z=FE_PHN44_num_computated_0 VSS=DVSS VDD=DVDD
XFE_PHC43_num_computated_5 DEL0 $PINS I=num_computated<5>
+ Z=FE_PHN43_num_computated_5 VSS=DVSS VDD=DVDD
XFE_PHC42_num_computated_2 DEL0 $PINS I=num_computated<2>
+ Z=FE_PHN42_num_computated_2 VSS=DVSS VDD=DVDD
XFE_PHC41_num_computated_4 DEL0 $PINS I=num_computated<4>
+ Z=FE_PHN41_num_computated_4 VSS=DVSS VDD=DVDD
XFE_PHC40_rstn BUFFD1 $PINS I=FE_PHN130_rstn Z=FE_PHN40_rstn VSS=DVSS VDD=DVDD
XFE_OFC39_b_col_idx_2 BUFFD12 $PINS I=FE_OFN39_b_col_idx_2 Z=b_col_idx<2>
+ VSS=DVSS VDD=DVDD
XFE_OFC38_a_col_idx_0 BUFFD12 $PINS I=FE_OFN38_a_col_idx_0 Z=a_col_idx<0>
+ VSS=DVSS VDD=DVDD
XFE_OFC37_a_col_idx_1 BUFFD12 $PINS I=FE_OFN37_a_col_idx_1 Z=a_col_idx<1>
+ VSS=DVSS VDD=DVDD
XFE_OFC36_a_col_idx_2 BUFFD12 $PINS I=FE_OFN36_a_col_idx_2 Z=a_col_idx<2>
+ VSS=DVSS VDD=DVDD
XFE_OFC35_b_col_idx_0 BUFFD12 $PINS I=FE_OFN35_b_col_idx_0 Z=b_col_idx<0>
+ VSS=DVSS VDD=DVDD
XFE_OFC34_b_col_idx_1 BUFFD12 $PINS I=FE_OFN34_b_col_idx_1 Z=b_col_idx<1>
+ VSS=DVSS VDD=DVDD
XCTS_ccl_a_inv_00003 CKND2 $PINS I=CTS_2 ZN=CTS_1 VSS=DVSS VDD=DVDD
XCTS_ccl_a_inv_00002 CKND2 $PINS I=CTS_2 ZN=CTS_4 VSS=DVSS VDD=DVDD
XCTS_ccl_a_inv_00001 CKND2 $PINS I=CTS_2 ZN=CTS_3 VSS=DVSS VDD=DVDD
XCTS_ccl_a_inv_00004 CKND2 $PINS I=CTS_5 ZN=CTS_2 VSS=DVSS VDD=DVDD
XCTS_ccl_a_inv_00005 CKND2 $PINS I=CTS_6 ZN=CTS_5 VSS=DVSS VDD=DVDD
XCTS_cmf_inv_00051 CKND1 $PINS I=clk ZN=CTS_6 VSS=DVSS VDD=DVDD
XLTIELO_5 TIEL $PINS ZN=FE_OFN35_b_col_idx_0 VSS=DVSS VDD=DVDD
XLTIELO_4 TIEL $PINS ZN=FE_OFN34_b_col_idx_1 VSS=DVSS VDD=DVDD
XLTIELO_3 TIEL $PINS ZN=FE_OFN39_b_col_idx_2 VSS=DVSS VDD=DVDD
XLTIELO_2 TIEL $PINS ZN=FE_OFN38_a_col_idx_0 VSS=DVSS VDD=DVDD
XLTIELO_1 TIEL $PINS ZN=FE_OFN37_a_col_idx_1 VSS=DVSS VDD=DVDD
XLTIELO TIEL $PINS ZN=FE_OFN36_a_col_idx_2 VSS=DVSS VDD=DVDD
XFE_OFC33_a_row_idx_3 CKND12 $PINS I=FE_OFN33_a_row_idx_3 ZN=a_row_idx<3>
+ VSS=DVSS VDD=DVDD
XFE_OFC32_a_row_idx_3 INVD1 $PINS I=FE_OFN32_a_row_idx_3
+ ZN=FE_OFN33_a_row_idx_3 VSS=DVSS VDD=DVDD
XFE_OFC31_a_row_idx_8 CKND12 $PINS I=FE_OFN31_a_row_idx_8 ZN=a_row_idx<8>
+ VSS=DVSS VDD=DVDD
XFE_OFC30_a_row_idx_8 INVD1 $PINS I=FE_PHN95_FE_OFN30_a_row_idx_8
+ ZN=FE_OFN31_a_row_idx_8 VSS=DVSS VDD=DVDD
XFE_OFC29_sram_rd_en CKBD12 $PINS I=FE_OFN29_sram_rd_en Z=sram_rd_en VSS=DVSS
+ VDD=DVDD
XFE_OFC28_b_col_idx_3 CKND12 $PINS I=FE_OFN28_b_col_idx_3 ZN=b_col_idx<3>
+ VSS=DVSS VDD=DVDD
XFE_OFC27_b_col_idx_3 INVD1 $PINS I=FE_OFN27_b_col_idx_3
+ ZN=FE_OFN28_b_col_idx_3 VSS=DVSS VDD=DVDD
XFE_OFC26_b_col_idx_4 CKND12 $PINS I=FE_OFN26_b_col_idx_4 ZN=b_col_idx<4>
+ VSS=DVSS VDD=DVDD
XFE_OFC25_b_col_idx_4 INVD1 $PINS I=FE_OFN25_b_col_idx_4
+ ZN=FE_OFN26_b_col_idx_4 VSS=DVSS VDD=DVDD
XFE_OFC24_b_col_idx_5 CKND12 $PINS I=FE_OFN24_b_col_idx_5 ZN=b_col_idx<5>
+ VSS=DVSS VDD=DVDD
XFE_OFC23_b_col_idx_5 INVD1 $PINS I=FE_OFN23_b_col_idx_5
+ ZN=FE_OFN24_b_col_idx_5 VSS=DVSS VDD=DVDD
XFE_OFC22_b_col_idx_6 CKND12 $PINS I=FE_OFN22_b_col_idx_6 ZN=b_col_idx<6>
+ VSS=DVSS VDD=DVDD
XFE_OFC21_b_col_idx_6 INVD1 $PINS I=FE_PHN104_FE_OFN21_b_col_idx_6
+ ZN=FE_OFN22_b_col_idx_6 VSS=DVSS VDD=DVDD
XFE_OFC20_b_col_idx_7 CKND12 $PINS I=FE_OFN20_b_col_idx_7 ZN=b_col_idx<7>
+ VSS=DVSS VDD=DVDD
XFE_OFC19_b_col_idx_7 INVD1 $PINS I=FE_PHN105_FE_OFN19_b_col_idx_7
+ ZN=FE_OFN20_b_col_idx_7 VSS=DVSS VDD=DVDD
XFE_OFC18_b_col_idx_8 CKND12 $PINS I=FE_OFN18_b_col_idx_8 ZN=b_col_idx<8>
+ VSS=DVSS VDD=DVDD
XFE_OFC17_b_col_idx_8 INVD1 $PINS I=FE_PHN103_FE_OFN17_b_col_idx_8
+ ZN=FE_OFN18_b_col_idx_8 VSS=DVSS VDD=DVDD
XFE_OFC16_a_row_idx_0 CKND12 $PINS I=FE_OFN15_a_row_idx_0 ZN=b_row_idx<0>
+ VSS=DVSS VDD=DVDD
XFE_OFC15_a_row_idx_0 CKND12 $PINS I=FE_OFN15_a_row_idx_0 ZN=a_row_idx<0>
+ VSS=DVSS VDD=DVDD
XFE_OFC14_a_row_idx_0 INVD1 $PINS I=FE_PHN47_FE_OFN14_a_row_idx_0
+ ZN=FE_OFN15_a_row_idx_0 VSS=DVSS VDD=DVDD
XFE_OFC13_a_row_idx_1 CKBD12 $PINS I=FE_RN_1 Z=a_row_idx<1> VSS=DVSS VDD=DVDD
XFE_OFC12_a_row_idx_1 CKND12 $PINS I=FE_OFN12_a_row_idx_1 ZN=FE_RN_1 VSS=DVSS
+ VDD=DVDD
XFE_OFC11_a_row_idx_1 INVD1 $PINS I=FE_PHN51_FE_OFN11_a_row_idx_1
+ ZN=FE_OFN12_a_row_idx_1 VSS=DVSS VDD=DVDD
XFE_OFC10_a_row_idx_2 CKND12 $PINS I=FE_OFN9_a_row_idx_2 ZN=b_row_idx<2>
+ VSS=DVSS VDD=DVDD
XFE_OFC9_a_row_idx_2 CKND12 $PINS I=FE_OFN9_a_row_idx_2 ZN=a_row_idx<2>
+ VSS=DVSS VDD=DVDD
XFE_OFC8_a_row_idx_2 INVD1 $PINS I=FE_PHN46_FE_OFN8_a_row_idx_2
+ ZN=FE_OFN9_a_row_idx_2 VSS=DVSS VDD=DVDD
XFE_OFC7_a_row_idx_4 CKND12 $PINS I=FE_OFN7_a_row_idx_4 ZN=a_row_idx<4>
+ VSS=DVSS VDD=DVDD
XFE_OFC6_a_row_idx_4 INVD1 $PINS I=FE_OFN6_a_row_idx_4 ZN=FE_OFN7_a_row_idx_4
+ VSS=DVSS VDD=DVDD
XFE_OFC5_a_row_idx_5 CKND12 $PINS I=FE_OFN5_a_row_idx_5 ZN=a_row_idx<5>
+ VSS=DVSS VDD=DVDD
XFE_OFC4_a_row_idx_5 INVD1 $PINS I=FE_OFN4_a_row_idx_5 ZN=FE_OFN5_a_row_idx_5
+ VSS=DVSS VDD=DVDD
XFE_OFC3_a_row_idx_6 CKND12 $PINS I=FE_OFN3_a_row_idx_6 ZN=a_row_idx<6>
+ VSS=DVSS VDD=DVDD
XFE_OFC2_a_row_idx_6 INVD1 $PINS I=FE_PHN96_FE_OFN2_a_row_idx_6
+ ZN=FE_OFN3_a_row_idx_6 VSS=DVSS VDD=DVDD
XFE_OFC1_a_row_idx_7 CKND12 $PINS I=FE_OFN1_a_row_idx_7 ZN=a_row_idx<7>
+ VSS=DVSS VDD=DVDD
XFE_OFC0_a_row_idx_7 INVD1 $PINS I=FE_PHN97_FE_OFN0_a_row_idx_7
+ ZN=FE_OFN1_a_row_idx_7 VSS=DVSS VDD=DVDD
Xp18161A__2398 IOA21D0 $PINS A1=n_344 A2=b_col_idx_temp<8> B=n_291 ZN=n_346
+ VSS=DVSS VDD=DVDD
Xnum_computated_reg[3] DFKCNQD1 $PINS CN=FE_PHN40_rstn CP=CTS_1
+ D=FE_PHN123_n_341 Q=num_computated<3> VSS=DVSS VDD=DVDD
Xp18171A__5107 OAI32D0 $PINS A1=FE_PHN71_n_89 A2=FE_PHN58_b_col_idx_temp_7
+ A3=n_273 B1=FE_PHN69_n_90 B2=n_343 ZN=n_345 VSS=DVSS VDD=DVDD
Xu_ac_z_reg[2] DFQD1 $PINS CP=CTS_4 D=n_338 Q=FE_OFN8_a_row_idx_2 VSS=DVSS
+ VDD=DVDD
Xu_ac_z_reg[1] DFQD1 $PINS CP=CTS_4 D=n_329 Q=FE_OFN11_a_row_idx_1 VSS=DVSS
+ VDD=DVDD
Xnum_computated_reg[4] DFKCNQD1 $PINS CN=FE_PHN40_rstn CP=CTS_1
+ D=FE_PHN120_n_320 Q=num_computated<4> VSS=DVSS VDD=DVDD
Xnum_computated_reg[2] DFKCNQD1 $PINS CN=FE_PHN40_rstn CP=CTS_1
+ D=FE_PHN119_n_318 Q=num_computated<2> VSS=DVSS VDD=DVDD
Xa_row_os_reg[8] DFKCNQD1 $PINS CN=FE_PHN40_rstn CP=CTS_3 D=FE_PHN124_n_311
+ Q=a_row_os<8> VSS=DVSS VDD=DVDD
Xp18154A__6260 OAI21D0 $PINS A1=FE_PHN114_n_322 A2=FE_PHN58_b_col_idx_temp_7
+ B=n_343 ZN=n_344 VSS=DVSS VDD=DVDD
Xp18177A__4319 AO22D0 $PINS A1=n_334 A2=n_244 B1=a_row_idx_temp<8> B2=n_315
+ Z=n_342 VSS=DVSS VDD=DVDD
Xp18161A5835__8428 IOA21D0 $PINS A1=FE_PHN116_n_319
+ A2=FE_PHN45_num_computated_3 B=n_316 ZN=n_341 VSS=DVSS VDD=DVDD
Xp18163A__5526 OAI32D1 $PINS A1=u_ac_i<4> A2=FE_PHN50_n_7 A3=n_332
+ B1=FE_PHN68_n_11 B2=n_325 ZN=n_340 VSS=DVSS VDD=DVDD
Xp18181A__6783 OAI32D0 $PINS A1=b_row_idx<7> A2=n_301 A3=n_337 B1=FE_PHN84_n_5
+ B2=n_314 ZN=n_339 VSS=DVSS VDD=DVDD
Xp18178A__3680 OAI22D0 $PINS A1=n_337 A2=n_101 B1=n_327 B2=FE_OFN9_a_row_idx_2
+ ZN=n_338 VSS=DVSS VDD=DVDD
Xa_row_os_reg[5] EDFKCNQD1 $PINS CN=FE_PHN40_rstn CP=CTS_3 D=FE_PHN101_n_239
+ E=n_336 Q=a_row_os<5> VSS=DVSS VDD=DVDD
Xa_row_os_reg[4] EDFKCNQD1 $PINS CN=FE_PHN40_rstn CP=CTS_3 D=FE_PHN102_n_178
+ E=n_336 Q=a_row_os<4> VSS=DVSS VDD=DVDD
Xnum_computated_reg[6] DFKCNQD1 $PINS CN=FE_PHN40_rstn CP=CTS_1
+ D=FE_PHN118_n_296 Q=num_computated<6> VSS=DVSS VDD=DVDD
Xb_col_os_reg[3] DFKCNQD1 $PINS CN=FE_PHN40_rstn CP=CTS_1 D=FE_PHN125_n_300
+ Q=b_col_os<3> VSS=DVSS VDD=DVDD
Xnum_computated_reg[5] DFKCNQD1 $PINS CN=FE_PHN40_rstn CP=CTS_1
+ D=FE_PHN122_n_297 Q=num_computated<5> VSS=DVSS VDD=DVDD
Xa_row_os_reg[3] DFKCNQD1 $PINS CN=FE_PHN40_rstn CP=CTS_1 D=n_298 Q=a_row_os<3>
+ VSS=DVSS VDD=DVDD
Xnum_computated_reg[1] DFKCNQD1 $PINS CN=FE_PHN40_rstn CP=CTS_1
+ D=FE_PHN121_n_295 Q=num_computated<1> VSS=DVSS VDD=DVDD
Xp18188A__1617 AO22D0 $PINS A1=n_330 A2=b_row_idx<3> B1=n_128 B2=n_334 Z=n_335
+ VSS=DVSS VDD=DVDD
Xp18197A__2802 OAI22D0 $PINS A1=n_323 A2=FE_PHN59_n_10 B1=n_332 B2=n_176
+ ZN=n_333 VSS=DVSS VDD=DVDD
Xp18177A5821__1705 AO22D0 $PINS A1=n_334 A2=n_365 B1=FE_PHN56_a_row_idx_temp_4
+ B2=n_330 Z=n_331 VSS=DVSS VDD=DVDD
Xp18170A__5122 OAI32D0 $PINS A1=FE_RN_1 A2=FE_OFN15_a_row_idx_0 A3=n_337
+ B1=n_52 B2=n_327 ZN=n_329 VSS=DVSS VDD=DVDD
Xp18187A__8246 OAI22D0 $PINS A1=n_325 A2=FE_PHN65_n_9 B1=n_332 B2=n_87 ZN=n_326
+ VSS=DVSS VDD=DVDD
Xp18174A__7098 OAI32D1 $PINS A1=a_col_idx<7> A2=n_305 A3=n_332 B1=FE_PHN70_n_6
+ B2=n_323 ZN=n_324 VSS=DVSS VDD=DVDD
Xu_ac_z_reg[0] DFQD1 $PINS CP=CTS_4 D=n_312 Q=FE_OFN14_a_row_idx_0 VSS=DVSS
+ VDD=DVDD
Xb_col_os_reg[5] EDFKCNQD1 $PINS CN=FE_PHN40_rstn CP=CTS_4 D=FE_PHN92_n_237
+ E=n_336 Q=b_col_os<5> VSS=DVSS VDD=DVDD
Xb_col_os_reg[4] EDFKCNQD1 $PINS CN=FE_PHN40_rstn CP=CTS_4 D=FE_PHN93_n_180
+ E=n_336 Q=b_col_os<4> VSS=DVSS VDD=DVDD
Xb_col_os_reg[8] EDFKCNQD1 $PINS CN=FE_PHN40_rstn CP=CTS_1 D=FE_PHN89_n_280
+ E=n_336 Q=b_col_os<8> VSS=DVSS VDD=DVDD
Xnum_computated_reg[0] DFKCNQD1 $PINS CN=FE_PHN40_rstn CP=CTS_3 D=n_299
+ Q=num_computated<0> VSS=DVSS VDD=DVDD
Xp18150A__6131 IAO21D0 $PINS A1=FE_PHN114_n_322 A2=FE_PHN88_b_col_idx_temp_6
+ B=n_321 ZN=n_343 VSS=DVSS VDD=DVDD
Xp18152A5836__1881 AO21D0 $PINS A1=FE_PHN116_n_319 A2=FE_PHN41_num_computated_4
+ B=n_310 Z=n_320 VSS=DVSS VDD=DVDD
Xp18152A__5115 AO21D0 $PINS A1=FE_PHN116_n_319 A2=FE_PHN42_num_computated_2
+ B=n_307 Z=n_318 VSS=DVSS VDD=DVDD
Xp18218A__7482 OAI32D0 $PINS A1=FE_PHN74_b_col_idx_temp_5 A2=n_276
+ A3=FE_PHN114_n_322 B1=n_267 B2=n_303 ZN=n_317 VSS=DVSS VDD=DVDD
Xp18135A__4733 OAI211D0 $PINS A1=FE_PHN45_num_computated_3 A2=n_306 B=n_336
+ C=n_309 ZN=n_316 VSS=DVSS VDD=DVDD
XFp18170A CKND0 $PINS I=n_314 ZN=n_315 VSS=DVSS VDD=DVDD
Xp13989A INVD12 $PINS I=FE_PHN79_n_349 ZN=done VSS=DVSS VDD=DVDD
Xp18254A__6161 OAI21D0 $PINS A1=n_294 A2=FE_OFN15_a_row_idx_0 B=n_289 ZN=n_312
+ VSS=DVSS VDD=DVDD
Xp18171A5844__9315 MOAI22D0 $PINS A1=FE_PHN116_n_319 A2=n_283
+ B1=FE_PHN116_n_319 B2=a_row_os<8> ZN=n_311 VSS=DVSS VDD=DVDD
Xp18097A__9945 AOI211D0 $PINS A1=n_309 A2=n_206 B=FE_PHN116_n_319 C=n_210
+ ZN=n_310 VSS=DVSS VDD=DVDD
Xp18222A__2883 AO21D0 $PINS A1=n_304 A2=a_col_idx<3> B=n_302 Z=n_308 VSS=DVSS
+ VDD=DVDD
Xp18097A5847__2346 AOI211D0 $PINS A1=n_78 A2=n_171 B=FE_PHN116_n_319 C=n_306
+ ZN=n_307 VSS=DVSS VDD=DVDD
Xdone_reg DFKCND1 $PINS CN=FE_PHN40_rstn CP=CTS_1 D=FE_PHN107_n_284
+ Q=UNCONNECTED QN=n_349 VSS=DVSS VDD=DVDD
Xp18191A__1666 AOI21D0 $PINS A1=n_271 A2=n_305 B=n_304 ZN=n_323 VSS=DVSS
+ VDD=DVDD
Xp18140A__7410 OAI21D0 $PINS A1=FE_PHN114_n_322 A2=FE_PHN74_b_col_idx_temp_5
+ B=n_303 ZN=n_321 VSS=DVSS VDD=DVDD
Xp18173A__6417 NR2D0 $PINS A1=n_302 A2=n_304 ZN=n_325 VSS=DVSS VDD=DVDD
Xp18178A5837__5477 AOI21D0 $PINS A1=n_334 A2=n_301 B=n_293 ZN=n_314 VSS=DVSS
+ VDD=DVDD
Xp18171A5841__2398 MOAI22D0 $PINS A1=FE_PHN116_n_319 A2=n_77 B1=FE_PHN116_n_319
+ B2=FE_PHN53_b_col_os_3 ZN=n_300 VSS=DVSS VDD=DVDD
Xp18171A5845__5107 MOAI22D0 $PINS A1=FE_PHN116_n_319
+ A2=FE_PHN44_num_computated_0 B1=FE_PHN116_n_319 B2=FE_PHN44_num_computated_0
+ ZN=n_299 VSS=DVSS VDD=DVDD
Xp18171A5839__6260 MOAI22D0 $PINS A1=FE_PHN116_n_319 A2=n_72 B1=FE_PHN116_n_319
+ B2=FE_PHN54_a_row_os_3 ZN=n_298 VSS=DVSS VDD=DVDD
Xp18171A5840__4319 MOAI22D0 $PINS A1=FE_PHN116_n_319 A2=n_211
+ B1=FE_PHN116_n_319 B2=FE_PHN43_num_computated_5 ZN=n_297 VSS=DVSS VDD=DVDD
Xp18171A5843__8428 MOAI22D0 $PINS A1=FE_PHN116_n_319 A2=n_223
+ B1=FE_PHN116_n_319 B2=num_computated<6> ZN=n_296 VSS=DVSS VDD=DVDD
Xp18171A5842__5526 MOAI22D0 $PINS A1=FE_PHN116_n_319 A2=n_74 B1=FE_PHN116_n_319
+ B2=num_computated<1> ZN=n_295 VSS=DVSS VDD=DVDD
Xp18161A5838__6783 IOA21D0 $PINS A1=n_334 A2=n_111 B=n_294 ZN=n_330 VSS=DVSS
+ VDD=DVDD
Xp18194A__3680 NR2D0 $PINS A1=n_288 A2=n_293 ZN=n_327 VSS=DVSS VDD=DVDD
Xp18252A__1617 MOAI22D0 $PINS A1=n_332 A2=n_368 B1=n_304 B2=u_ac_i<6> ZN=n_292
+ VSS=DVSS VDD=DVDD
Xp18225A__2802 IND4D0 $PINS A1=b_col_idx_temp<8> B1=FE_PHN126_n_290
+ B2=FE_PHN58_b_col_idx_temp_7 B3=FE_PHN88_b_col_idx_temp_6 ZN=n_291 VSS=DVSS
+ VDD=DVDD
XFp18194A CKND0 $PINS I=n_288 ZN=n_289 VSS=DVSS VDD=DVDD
Xp18247A5846__1705 MOAI22D0 $PINS A1=n_337 A2=n_362 B1=n_293
+ B2=FE_PHN77_a_row_idx_temp_6 ZN=n_287 VSS=DVSS VDD=DVDD
Xp18247A__5122 MOAI22D0 $PINS A1=n_337 A2=n_363 B1=n_293
+ B2=FE_PHN78_a_row_idx_temp_5 ZN=n_286 VSS=DVSS VDD=DVDD
Xp18182A__8246 IND2D0 $PINS A1=FE_PHN107_n_284 B1=FE_PHN40_rstn ZN=n_285
+ VSS=DVSS VDD=DVDD
Xp18287A__7098 MAOI22D0 $PINS A1=n_282 A2=n_281 B1=n_282 B2=n_281 ZN=n_283
+ VSS=DVSS VDD=DVDD
Xp18294A__6131 MOAI22D0 $PINS A1=n_279 A2=n_278 B1=n_279 B2=n_278 ZN=n_280
+ VSS=DVSS VDD=DVDD
XFp18065A INVD1 $PINS I=FE_PHN116_n_319 ZN=n_336 VSS=DVSS VDD=DVDD
Xp18124A__1881 AOI21D0 $PINS A1=n_277 A2=n_276 B=n_275 ZN=n_303 VSS=DVSS
+ VDD=DVDD
Xp18159A__5115 NR2D0 $PINS A1=n_332 A2=FE_PHN48_u_ac_i_3 ZN=n_302 VSS=DVSS
+ VDD=DVDD
Xp18184A__7482 NR2D0 $PINS A1=n_337 A2=FE_PHN47_FE_OFN14_a_row_idx_0 ZN=n_288
+ VSS=DVSS VDD=DVDD
XFp18219A CKND0 $PINS I=FE_PHN126_n_290 ZN=n_273 VSS=DVSS VDD=DVDD
Xp18113A__4733 INR3D0 $PINS A1=n_268 B1=n_269 B2=n_270 ZN=n_284 VSS=DVSS
+ VDD=DVDD
XFp18126A CKND0 $PINS I=n_337 ZN=n_334 VSS=DVSS VDD=DVDD
Xp18292A__6161 MOAI22D0 $PINS A1=FE_PHN114_n_322 A2=n_76 B1=n_275
+ B2=FE_PHN62_b_col_idx_temp_4 ZN=n_272 VSS=DVSS VDD=DVDD
XFp18150A CKND0 $PINS I=n_332 ZN=n_271 VSS=DVSS VDD=DVDD
Xp17858A__9315 IND3D1 $PINS A1=n_270 B1=n_269 B2=n_268 ZN=n_319 VSS=DVSS
+ VDD=DVDD
Xp18163A5848__9945 NR3D0 $PINS A1=FE_PHN114_n_322 A2=n_276 A3=n_267 ZN=n_290
+ VSS=DVSS VDD=DVDD
Xp18191A5849__2883 NR2D0 $PINS A1=n_268 A2=n_263 ZN=n_304 VSS=DVSS VDD=DVDD
Xp18101A__2346 CKND2D0 $PINS A1=n_275 A2=n_294 ZN=n_337 VSS=DVSS VDD=DVDD
Xp18107A__1666 ND3D0 $PINS A1=n_268 A2=n_270 A3=FE_PHN40_rstn ZN=n_332 VSS=DVSS
+ VDD=DVDD
Xp18252A5851__7410 FA1D0 $PINS A=b_col_os<7> B=k<4> CI=n_259 CO=n_279 S=n_266
+ VSS=DVSS VDD=DVDD
Xp18238A__6417 FA1D0 $PINS A=FE_PHN66_a_row_os_7 B=n<4> CI=n_257 CO=n_282
+ S=n_265 VSS=DVSS VDD=DVDD
XFp18109A CKND0 $PINS I=FE_PHN114_n_322 ZN=n_277 VSS=DVSS VDD=DVDD
Xp18067A__5477 ND3D0 $PINS A1=FE_PHN99_n_264 A2=n_262 A3=FE_PHN40_rstn ZN=n_322
+ VSS=DVSS VDD=DVDD
Xp18070A__2398 NR2D0 $PINS A1=FE_PHN99_n_264 A2=n_263 ZN=n_275 VSS=DVSS
+ VDD=DVDD
Xp17796A__5107 INR2D0 $PINS A1=FE_PHN99_n_264 B1=n_262 ZN=n_268 VSS=DVSS
+ VDD=DVDD
Xp17763A__6260 INR3D0 $PINS A1=sram_rd_en B1=n_163 B2=n_256 ZN=n_264 VSS=DVSS
+ VDD=DVDD
Xp18210A__4319 FA1D0 $PINS A=FE_PHN67_b_col_os_6 B=k<3> CI=n_236 CO=n_259
+ S=n_260 VSS=DVSS VDD=DVDD
Xp18196A__8428 FA1D0 $PINS A=FE_PHN60_a_row_os_6 B=n<3> CI=n_238 CO=n_257
+ S=n_258 VSS=DVSS VDD=DVDD
Xp17743A__5526 OAI211D0 $PINS A1=n<6> A2=n_160 B=n_253 C=n_184 ZN=n_256
+ VSS=DVSS VDD=DVDD
Xp17920A__3680 OAI211D0 $PINS A1=m<6> A2=n_193 B=n_241 C=n_194 ZN=n_270
+ VSS=DVSS VDD=DVDD
Xp13248A__1617 OR2XD1 $PINS A1=n_251 A2=n_247 Z=FE_OFN17_b_col_idx_8 VSS=DVSS
+ VDD=DVDD
Xp17896A__2802 OAI211D0 $PINS A1=k<0> A2=FE_PHN52_b_col_idx_temp_3 B=n_240
+ C=n_196 ZN=n_262 VSS=DVSS VDD=DVDD
Xp18033A__1705 ND4D0 $PINS A1=n_235 A2=n_197 A3=n_217 A4=n_207 ZN=n_269
+ VSS=DVSS VDD=DVDD
Xp17708A__5122 AOI211D0 $PINS A1=n_137 A2=b_row_idx<3> B=n_234 C=n_138 ZN=n_253
+ VSS=DVSS VDD=DVDD
Xp13247A__7098 CKAN2D0 $PINS A1=n_246 A2=n_245 Z=n_251 VSS=DVSS VDD=DVDD
Xp13239A__1881 NR2D0 $PINS A1=n_246 A2=n_245 ZN=n_247 VSS=DVSS VDD=DVDD
Xp18396A__5115 OAI32D0 $PINS A1=b_row_idx<8> A2=FE_PHN84_n_5 A3=n_301
+ B1=b_row_idx<7> B2=FE_PHN81_n_4 ZN=n_244 VSS=DVSS VDD=DVDD
Xp13291A__7482 OR2XD1 $PINS A1=n_231 A2=n_233 Z=FE_OFN0_a_row_idx_7 VSS=DVSS
+ VDD=DVDD
Xp13293A__4733 OR2XD1 $PINS A1=n_229 A2=n_227 Z=FE_OFN19_b_col_idx_7 VSS=DVSS
+ VDD=DVDD
Xp17770A__6161 AOI221D0 $PINS A1=n_218 A2=a_col_idx<3> B1=n_165 B2=n_164
+ C=n_219 ZN=n_241 VSS=DVSS VDD=DVDD
Xp17747A__9315 AOI221D0 $PINS A1=n_156 A2=FE_PHN52_b_col_idx_temp_3 B1=n_213
+ B2=n_212 C=n_214 ZN=n_240 VSS=DVSS VDD=DVDD
Xp18154A5855__9945 FA1D0 $PINS A=FE_PHN72_a_row_os_5 B=n<2> CI=n_177 CO=n_238
+ S=n_239 VSS=DVSS VDD=DVDD
Xp18169A__2883 FA1D0 $PINS A=FE_PHN76_b_col_os_5 B=k<2> CI=n_179 CO=n_236
+ S=n_237 VSS=DVSS VDD=DVDD
Xp13222A__1666 IOA21D0 $PINS A1=n_228 A2=n_99 B=n_98 ZN=n_246 VSS=DVSS VDD=DVDD
Xp18008A__7410 AOI221D0 $PINS A1=n_3 A2=n_1 B1=FE_PHN45_num_computated_3
+ B2=n_208 C=n_209 ZN=n_235 VSS=DVSS VDD=DVDD
Xp17629A__6417 OAI221D0 $PINS A1=n_154 A2=n_153 B1=n<0> B2=n_169 C=n_215
+ ZN=n_234 VSS=DVSS VDD=DVDD
Xp13281A__5477 NR2D0 $PINS A1=n_232 A2=n_230 ZN=n_233 VSS=DVSS VDD=DVDD
Xp13290A__2398 CKAN2D0 $PINS A1=n_232 A2=n_230 Z=n_231 VSS=DVSS VDD=DVDD
Xp13290A5852__5107 CKAN2D0 $PINS A1=n_228 A2=n_226 Z=n_229 VSS=DVSS VDD=DVDD
Xp13282A__6260 NR2D0 $PINS A1=n_228 A2=n_226 ZN=n_227 VSS=DVSS VDD=DVDD
Xp13335A__4319 OR2XD1 $PINS A1=n_203 A2=n_201 Z=FE_OFN2_a_row_idx_6 VSS=DVSS
+ VDD=DVDD
Xp13336A__8428 OR2XD1 $PINS A1=n_199 A2=n_205 Z=FE_OFN21_b_col_idx_6 VSS=DVSS
+ VDD=DVDD
Xp18357A__5526 MAOI22D0 $PINS A1=n_222 A2=num_computated<6> B1=n_222
+ B2=num_computated<6> ZN=n_223 VSS=DVSS VDD=DVDD
Xp17693A__3680 OAI221D0 $PINS A1=n_191 A2=n_190 B1=FE_PHN48_u_ac_i_3 B2=n_218
+ C=n_192 ZN=n_219 VSS=DVSS VDD=DVDD
Xp18091A__1617 MAOI22D0 $PINS A1=FE_PHN43_num_computated_5 A2=n_216
+ B1=FE_PHN43_num_computated_5 B2=n_216 ZN=n_217 VSS=DVSS VDD=DVDD
Xp17617A__2802 IAO21D0 $PINS A1=n_132 A2=n_131 B=n_195 ZN=n_215 VSS=DVSS
+ VDD=DVDD
Xp17670A__1705 OAI221D0 $PINS A1=n_213 A2=n_212 B1=n_187 B2=n_188 C=n_189
+ ZN=n_214 VSS=DVSS VDD=DVDD
Xp18374A__5122 OAI21D0 $PINS A1=n_210 A2=FE_PHN43_num_computated_5 B=n_222
+ ZN=n_211 VSS=DVSS VDD=DVDD
Xp13196A__8246 IOA21D0 $PINS A1=n_202 A2=n_93 B=n_92 ZN=n_232 VSS=DVSS VDD=DVDD
Xp13197A__7098 IOA21D0 $PINS A1=n_204 A2=n_97 B=n_96 ZN=n_228 VSS=DVSS VDD=DVDD
Xp18014A__6131 OAI211D0 $PINS A1=n_208 A2=FE_PHN45_num_computated_3 B=n_174
+ C=n_172 ZN=n_209 VSS=DVSS VDD=DVDD
Xp18093A__1881 MUX2ND0 $PINS I0=n_206 I1=FE_PHN41_num_computated_4 S=n_173
+ ZN=n_207 VSS=DVSS VDD=DVDD
Xp18356A__5115 IND2D0 $PINS A1=n_220 B1=b_row_idx<6> ZN=n_301 VSS=DVSS VDD=DVDD
Xp13327A5853__7482 CKAN2D0 $PINS A1=n_204 A2=n_198 Z=n_205 VSS=DVSS VDD=DVDD
Xp13334A__4733 NR2D0 $PINS A1=n_202 A2=n_200 ZN=n_203 VSS=DVSS VDD=DVDD
Xp13327A__6161 CKAN2D0 $PINS A1=n_202 A2=n_200 Z=n_201 VSS=DVSS VDD=DVDD
Xp13336A5854__9315 NR2D0 $PINS A1=n_204 A2=n_198 ZN=n_199 VSS=DVSS VDD=DVDD
Xp18041A__9945 XNR3D0 $PINS A1=n_183 A2=num_computation<6> A3=num_computated<6>
+ ZN=n_197 VSS=DVSS VDD=DVDD
Xp17886A__2883 OA211D0 $PINS A1=n_139 A2=n_140 B=n_141 C=n_367 Z=n_196 VSS=DVSS
+ VDD=DVDD
Xp17595A__2346 OAI211D0 $PINS A1=n_151 A2=n_152 B=n_155 C=n_133 ZN=n_195
+ VSS=DVSS VDD=DVDD
Xp17905A__1666 AOI211D0 $PINS A1=n_193 A2=m<6> B=n_366 C=n_369 ZN=n_194
+ VSS=DVSS VDD=DVDD
Xp17562A__7410 AOI221D0 $PINS A1=n_167 A2=n_166 B1=n_191 B2=n_190 C=n_168
+ ZN=n_192 VSS=DVSS VDD=DVDD
Xp17540A__6417 AOI221D0 $PINS A1=n_158 A2=n_157 B1=n_188 B2=n_187 C=n_159
+ ZN=n_189 VSS=DVSS VDD=DVDD
Xp17844A__2398 AOI22D0 $PINS A1=n_162 A2=n_161 B1=n_129 B2=n<0> ZN=n_184
+ VSS=DVSS VDD=DVDD
Xp18270A__5107 AOI21D0 $PINS A1=n_147 A2=num_computation<5> B=n_183 ZN=n_216
+ VSS=DVSS VDD=DVDD
Xp18304A__6260 IND2D0 $PINS A1=n_185 B1=b_row_idx<5> ZN=n_220 VSS=DVSS VDD=DVDD
Xp13382A__4319 OR2XD1 $PINS A1=n_126 A2=n_146 Z=FE_OFN4_a_row_idx_5 VSS=DVSS
+ VDD=DVDD
Xp13383A__8428 OR2XD1 $PINS A1=n_127 A2=n_144 Z=FE_OFN23_b_col_idx_5 VSS=DVSS
+ VDD=DVDD
Xp18355A__5526 CKND2D0 $PINS A1=n_210 A2=FE_PHN43_num_computated_5 ZN=n_222
+ VSS=DVSS VDD=DVDD
Xp18107A5858__6783 FA1D0 $PINS A=FE_PHN75_b_col_os_4 B=k<1> CI=n_65 CO=n_179
+ S=n_180 VSS=DVSS VDD=DVDD
Xp18091A5857__3680 FA1D0 $PINS A=FE_PHN73_a_row_os_4 B=n<1> CI=n_59 CO=n_177
+ S=n_178 VSS=DVSS VDD=DVDD
Xp18434A__1617 OA32D0 $PINS A1=u_ac_i<8> A2=FE_PHN70_n_6 A3=n_305
+ B1=a_col_idx<7> B2=FE_PHN59_n_10 Z=n_176 VSS=DVSS VDD=DVDD
Xp13399A5860__2802 OR2XD1 $PINS A1=n_466 A2=n_122 Z=FE_OFN6_a_row_idx_4
+ VSS=DVSS VDD=DVDD
Xp13184A__1705 OAI21D0 $PINS A1=n_145 A2=n_79 B=n_80 ZN=n_202 VSS=DVSS VDD=DVDD
Xp13185A__5122 OAI21D0 $PINS A1=n_143 A2=n_83 B=n_84 ZN=n_204 VSS=DVSS VDD=DVDD
Xp17899A__8246 AOI221D0 $PINS A1=FE_PHN44_num_computated_0
+ A2=num_computation<0> B1=num_computated<1> B2=n_119 C=n_120 ZN=n_174 VSS=DVSS
+ VDD=DVDD
Xp18275A__7098 AOI21D0 $PINS A1=n_125 A2=num_computation<4> B=n_130 ZN=n_173
+ VSS=DVSS VDD=DVDD
Xp18019A__6131 MUX2ND0 $PINS I0=n_171 I1=FE_PHN42_num_computated_2 S=n_124
+ ZN=n_172 VSS=DVSS VDD=DVDD
Xp17562A5859__5115 OAI22D0 $PINS A1=n_167 A2=n_166 B1=n_165 B2=n_164 ZN=n_168
+ VSS=DVSS VDD=DVDD
Xp17911A__7482 MOAI22D0 $PINS A1=n_162 A2=n_161 B1=n_160 B2=n<6> ZN=n_163
+ VSS=DVSS VDD=DVDD
Xp17541A__4733 OAI22D0 $PINS A1=n_158 A2=n_157 B1=n_156
+ B2=FE_PHN52_b_col_idx_temp_3 ZN=n_159 VSS=DVSS VDD=DVDD
Xp17584A__6161 AOI22D0 $PINS A1=n_154 A2=n_153 B1=n_152 B2=n_151 ZN=n_155
+ VSS=DVSS VDD=DVDD
Xp18208A__9945 NR2D0 $PINS A1=n_147 A2=num_computation<5> ZN=n_183 VSS=DVSS
+ VDD=DVDD
Xp13373A__2883 NR2D0 $PINS A1=n_145 A2=n_104 ZN=n_146 VSS=DVSS VDD=DVDD
Xp13375A__2346 NR2D0 $PINS A1=n_143 A2=n_102 ZN=n_144 VSS=DVSS VDD=DVDD
Xp13399A__1666 OR2XD1 $PINS A1=n_118 A2=n_117 Z=FE_OFN25_b_col_idx_4 VSS=DVSS
+ VDD=DVDD
Xp17874A__7410 AOI22D0 $PINS A1=n_140 A2=n_139 B1=FE_PHN52_b_col_idx_temp_3
+ B2=k<0> ZN=n_141 VSS=DVSS VDD=DVDD
Xp18328A__6417 NR2D0 $PINS A1=n_309 A2=n_206 ZN=n_210 VSS=DVSS VDD=DVDD
Xp18290A5863__5477 CKND2D0 $PINS A1=n_169 A2=FE_PHN56_a_row_idx_temp_4 ZN=n_185
+ VSS=DVSS VDD=DVDD
Xp17811A__2398 NR2D0 $PINS A1=n_137 A2=FE_PHN49_a_row_idx_temp_3 ZN=n_138
+ VSS=DVSS VDD=DVDD
Xp17626A__4319 CKND2D0 $PINS A1=n_132 A2=n_131 ZN=n_133 VSS=DVSS VDD=DVDD
XFp18204A CKND0 $PINS I=n_147 ZN=n_130 VSS=DVSS VDD=DVDD
XFp17819A CKND0 $PINS I=n_128 ZN=n_129 VSS=DVSS VDD=DVDD
Xp13380A__8428 NR2D0 $PINS A1=n_112 A2=n_103 ZN=n_127 VSS=DVSS VDD=DVDD
Xp13378A__5526 NR2D0 $PINS A1=n_110 A2=n_105 ZN=n_126 VSS=DVSS VDD=DVDD
Xp18264A__6783 OA21D0 $PINS A1=n_123 A2=n_109 B=n_125 Z=n_208 VSS=DVSS VDD=DVDD
Xp18226A__3680 AOI21D0 $PINS A1=n_63 A2=num_computation<2> B=n_123 ZN=n_124
+ VSS=DVSS VDD=DVDD
Xp13392A__1617 NR2D0 $PINS A1=n_107 A2=n_121 ZN=n_122 VSS=DVSS VDD=DVDD
Xp17917A__2802 NR2D0 $PINS A1=num_computated<1> A2=n_119 ZN=n_120 VSS=DVSS
+ VDD=DVDD
Xp13397A5862__1705 INR2D0 $PINS A1=n_115 B1=n_116 ZN=n_118 VSS=DVSS VDD=DVDD
Xp13367A__5122 INR2D0 $PINS A1=n_116 B1=n_115 ZN=n_117 VSS=DVSS VDD=DVDD
XFp13166A5856 CKND0 $PINS I=n_112 ZN=n_143 VSS=DVSS VDD=DVDD
Xp17804A__7098 NR2D0 $PINS A1=n_111 A2=FE_PHN49_a_row_idx_temp_3 ZN=n_128
+ VSS=DVSS VDD=DVDD
XFp13166A CKND0 $PINS I=n_110 ZN=n_145 VSS=DVSS VDD=DVDD
Xp18170A5865__6131 IND3D0 $PINS A1=num_computation<4> B1=n_109 B2=n_123
+ ZN=n_147 VSS=DVSS VDD=DVDD
XFp18360A CKND0 $PINS I=n_293 ZN=n_294 VSS=DVSS VDD=DVDD
Xp18318A__1881 CKND2D0 $PINS A1=n_306 A2=FE_PHN45_num_computated_3 ZN=n_309
+ VSS=DVSS VDD=DVDD
Xp17702A__5115 NR2D0 $PINS A1=n_111 A2=FE_PHN55_n_2 ZN=n_169 VSS=DVSS VDD=DVDD
Xp13469A__7482 AN2XD1 $PINS A1=n_467 A2=n_121 Z=FE_OFN32_a_row_idx_3 VSS=DVSS
+ VDD=DVDD
XFp13384A5866 CKND0 $PINS I=n_104 ZN=n_105 VSS=DVSS VDD=DVDD
XFp13384A CKND0 $PINS I=n_102 ZN=n_103 VSS=DVSS VDD=DVDD
Xp18568A__4733 AOI32D0 $PINS A1=FE_OFN9_a_row_idx_2 A2=FE_RN_1
+ A3=FE_PHN47_FE_OFN14_a_row_idx_0 B1=n_52 B2=FE_PHN46_FE_OFN8_a_row_idx_2
+ ZN=n_101 VSS=DVSS VDD=DVDD
Xp13168A__6161 OAI21D0 $PINS A1=n_82 A2=n_115 B=n_81 ZN=n_112 VSS=DVSS VDD=DVDD
Xp18270A5864__9315 CKND2D0 $PINS A1=n_123 A2=n_109 ZN=n_125 VSS=DVSS VDD=DVDD
Xp17509A__9945 AOI21D0 $PINS A1=FE_PHN63_n_16 A2=m<3> B=n_190 ZN=n_165 VSS=DVSS
+ VDD=DVDD
Xp13383A5869__2883 CKND2D0 $PINS A1=n_99 A2=n_98 ZN=n_226 VSS=DVSS VDD=DVDD
Xp13389A__2346 CKND2D0 $PINS A1=n_97 A2=n_96 ZN=n_198 VSS=DVSS VDD=DVDD
Xp13383A5870__1666 CKND2D0 $PINS A1=n_95 A2=n_94 ZN=n_230 VSS=DVSS VDD=DVDD
Xp13388A__7410 CKND2D0 $PINS A1=n_93 A2=n_92 ZN=n_200 VSS=DVSS VDD=DVDD
Xp17720A__6417 AOI21D0 $PINS A1=FE_PHN68_n_11 A2=m<1> B=n_166 ZN=n_218 VSS=DVSS
+ VDD=DVDD
Xp13167A__5477 OAI21D0 $PINS A1=n_85 A2=n_121 B=n_86 ZN=n_110 VSS=DVSS VDD=DVDD
Xp18382A__2398 IND2D0 $PINS A1=n_113 B1=u_ac_i<6> ZN=n_305 VSS=DVSS VDD=DVDD
Xp13473A__5107 AN2XD1 $PINS A1=n_468 A2=n_115 Z=FE_OFN27_b_col_idx_3 VSS=DVSS
+ VDD=DVDD
Xp17516A__6260 AOI21D0 $PINS A1=FE_PHN65_n_9 A2=m<2> B=n_164 ZN=n_167 VSS=DVSS
+ VDD=DVDD
Xp17570A__4319 AOI21D0 $PINS A1=n_5 A2=n<4> B=n_161 ZN=n_152 VSS=DVSS VDD=DVDD
Xp17860A__8428 AOI21D0 $PINS A1=n_57 A2=k<5> B=n_68 ZN=n_140 VSS=DVSS VDD=DVDD
Xp17490A__5526 AOI21D0 $PINS A1=FE_PHN57_n_75 A2=k<1> B=n_69 ZN=n_156 VSS=DVSS
+ VDD=DVDD
Xp17760A__6783 AOI21D0 $PINS A1=FE_PHN82_n_0 A2=n<1> B=n_153 ZN=n_137 VSS=DVSS
+ VDD=DVDD
Xp17592A__3680 AOI21D0 $PINS A1=FE_PHN69_n_90 A2=k<4> B=n_139 ZN=n_188 VSS=DVSS
+ VDD=DVDD
Xp17612A__1617 AOI21D0 $PINS A1=FE_PHN70_n_6 A2=m<4> B=n_67 ZN=n_191 VSS=DVSS
+ VDD=DVDD
Xp17864A__2802 AOI21D0 $PINS A1=FE_PHN59_n_10 A2=m<5> B=n_70 ZN=n_149 VSS=DVSS
+ VDD=DVDD
Xp17583A__1705 AOI21D0 $PINS A1=FE_PHN83_n_33 A2=n<2> B=n_131 ZN=n_154 VSS=DVSS
+ VDD=DVDD
Xp17502A__5122 AOI21D0 $PINS A1=FE_PHN71_n_89 A2=k<3> B=n_187 ZN=n_158 VSS=DVSS
+ VDD=DVDD
Xp17613A__8246 AOI21D0 $PINS A1=FE_PHN85_n_29 A2=n<3> B=n_151 ZN=n_132 VSS=DVSS
+ VDD=DVDD
Xp17844A5874__7098 AOI21D0 $PINS A1=FE_PHN81_n_4 A2=n<5> B=n_71 ZN=n_162
+ VSS=DVSS VDD=DVDD
Xp17736A__6131 AO21D0 $PINS A1=n_267 A2=k<2> B=n_157 Z=n_213 VSS=DVSS VDD=DVDD
Xp18325A__1881 NR2D0 $PINS A1=sram_rd_en A2=n_263 ZN=n_293 VSS=DVSS VDD=DVDD
Xp13989A5868 INVD12 $PINS I=FE_PHN80_n_348 ZN=alu_start VSS=DVSS VDD=DVDD
Xp18553A__5115 AOI32D0 $PINS A1=FE_PHN65_n_9 A2=u_ac_i<4> A3=FE_PHN48_u_ac_i_3
+ B1=FE_PHN68_n_11 B2=a_col_idx<5> ZN=n_87 VSS=DVSS VDD=DVDD
Xp13360A__7482 INR2D0 $PINS A1=n_86 B1=n_85 ZN=n_107 VSS=DVSS VDD=DVDD
Xp13356A__4733 INR2D0 $PINS A1=n_84 B1=n_83 ZN=n_102 VSS=DVSS VDD=DVDD
Xp13354A__6161 IND2D0 $PINS A1=n_82 B1=n_81 ZN=n_116 VSS=DVSS VDD=DVDD
Xp13356A5871__9315 INR2D0 $PINS A1=n_80 B1=n_79 ZN=n_104 VSS=DVSS VDD=DVDD
Xp18154A5872__9945 AOI21D0 $PINS A1=num_computation<1> A2=num_computation<0>
+ B=n_62 ZN=n_119 VSS=DVSS VDD=DVDD
Xp17692A__2883 ND3D0 $PINS A1=FE_PHN46_FE_OFN8_a_row_idx_2 A2=FE_RN_1
+ A3=FE_PHN47_FE_OFN14_a_row_idx_0 ZN=n_111 VSS=DVSS VDD=DVDD
Xp18290A__2346 NR2D0 $PINS A1=n_78 A2=n_171 ZN=n_306 VSS=DVSS VDD=DVDD
Xp18494A5873__1666 OAI21D0 $PINS A1=FE_PHN53_b_col_os_3 A2=k<0> B=n_64 ZN=n_77
+ VSS=DVSS VDD=DVDD
Xp18584A__7410 AOI22D0 $PINS A1=FE_PHN57_n_75 A2=FE_PHN52_b_col_idx_temp_3
+ B1=FE_PHN64_n_60 B2=FE_PHN62_b_col_idx_temp_4 ZN=n_76 VSS=DVSS VDD=DVDD
Xp18488A__6417 OAI21D0 $PINS A1=FE_PHN44_num_computated_0 A2=num_computated<1>
+ B=n_78 ZN=n_74 VSS=DVSS VDD=DVDD
Xp18494A__2398 OAI21D0 $PINS A1=FE_PHN54_a_row_os_3 A2=FE_PHN128_n_0
+ B=FE_PHN86_n_58 ZN=n_72 VSS=DVSS VDD=DVDD
XFp17858A CKND0 $PINS I=n_71 ZN=n_160 VSS=DVSS VDD=DVDD
XFp17873A CKND0 $PINS I=n_70 ZN=n_193 VSS=DVSS VDD=DVDD
XFp17499A CKND0 $PINS I=n_69 ZN=n_212 VSS=DVSS VDD=DVDD
Xalu_start_reg DFKCND1 $PINS CN=FE_PHN94_tpu_start CP=CTS_1 D=FE_PHN40_rstn
+ Q=UNCONNECTED0 QN=n_348 VSS=DVSS VDD=DVDD
Xp18431A__6260 MOAI22D0 $PINS A1=b_col_os<8> A2=k<5> B1=b_col_os<8> B2=k<5>
+ ZN=n_278 VSS=DVSS VDD=DVDD
Xp18428A__4319 MOAI22D0 $PINS A1=a_row_os<8> A2=n<5> B1=a_row_os<8> B2=n<5>
+ ZN=n_281 VSS=DVSS VDD=DVDD
Xp17840A__8428 NR2D0 $PINS A1=FE_PHN81_n_4 A2=n<5> ZN=n_71 VSS=DVSS VDD=DVDD
Xp13274A__6783 CKND2D0 $PINS A1=FE_PHN85_n_29 A2=n_8 ZN=n_93 VSS=DVSS VDD=DVDD
Xp17598A__3680 NR2D0 $PINS A1=FE_PHN70_n_6 A2=m<4> ZN=n_67 VSS=DVSS VDD=DVDD
Xp13377A__1617 MOAI22D0 $PINS A1=b_col_idx_temp<8> A2=b_col_os<8>
+ B1=b_col_idx_temp<8> B2=b_col_os<8> ZN=n_245 VSS=DVSS VDD=DVDD
Xp17516A5877__2802 NR2D0 $PINS A1=FE_PHN65_n_9 A2=m<2> ZN=n_164 VSS=DVSS
+ VDD=DVDD
Xp13496A__1705 AN2XD1 $PINS A1=FE_PHN61_n_30 A2=tpu_start Z=FE_OFN29_sram_rd_en
+ VSS=DVSS VDD=DVDD
Xp17568A__5122 NR2D0 $PINS A1=FE_PHN69_n_90 A2=k<4> ZN=n_139 VSS=DVSS VDD=DVDD
Xp17584A5878__8246 NR2D0 $PINS A1=FE_PHN85_n_29 A2=n<3> ZN=n_151 VSS=DVSS
+ VDD=DVDD
Xp17545A__7098 NR2D0 $PINS A1=FE_PHN84_n_5 A2=n<4> ZN=n_161 VSS=DVSS VDD=DVDD
Xp18364A__6131 ND3D0 $PINS A1=u_ac_i<5> A2=u_ac_i<4> A3=a_col_idx<3> ZN=n_113
+ VSS=DVSS VDD=DVDD
Xp18098A__1881 NR3D0 $PINS A1=num_computation<0> A2=num_computation<2>
+ A3=num_computation<1> ZN=n_123 VSS=DVSS VDD=DVDD
XFp18131A CKND0 $PINS I=n_64 ZN=n_65 VSS=DVSS VDD=DVDD
XFp18167A CKND0 $PINS I=n_62 ZN=n_63 VSS=DVSS VDD=DVDD
XFp18115A CKND0 $PINS I=FE_PHN86_n_58 ZN=n_59 VSS=DVSS VDD=DVDD
Xp13343A__7482 CKND2D0 $PINS A1=FE_PHN69_n_90 A2=n_25 ZN=n_99 VSS=DVSS VDD=DVDD
Xp13277A__4733 CKND2D0 $PINS A1=n_48 A2=FE_PHN71_n_89 ZN=n_97 VSS=DVSS VDD=DVDD
Xp13343A5885__6161 CKND2D0 $PINS A1=n_5 A2=n_19 ZN=n_95 VSS=DVSS VDD=DVDD
Xp17852A__9315 NR2D0 $PINS A1=n_57 A2=k<5> ZN=n_68 VSS=DVSS VDD=DVDD
Xp17855A__9945 NR2D0 $PINS A1=FE_PHN59_n_10 A2=m<5> ZN=n_70 VSS=DVSS VDD=DVDD
Xp17503A__2883 NR2D0 $PINS A1=FE_PHN57_n_75 A2=k<1> ZN=n_69 VSS=DVSS VDD=DVDD
Xp17542A__2346 NR2D0 $PINS A1=n_267 A2=k<2> ZN=n_157 VSS=DVSS VDD=DVDD
Xp17609A__1666 NR2D0 $PINS A1=FE_PHN82_n_0 A2=n<1> ZN=n_153 VSS=DVSS VDD=DVDD
Xp17557A__7410 NR2D0 $PINS A1=FE_PHN68_n_11 A2=m<1> ZN=n_166 VSS=DVSS VDD=DVDD
Xp17512A__6417 NR2D0 $PINS A1=FE_PHN71_n_89 A2=k<3> ZN=n_187 VSS=DVSS VDD=DVDD
Xp17509A5879__5477 NR2D0 $PINS A1=FE_PHN63_n_16 A2=m<3> ZN=n_190 VSS=DVSS
+ VDD=DVDD
Xp17564A__2398 NR2D0 $PINS A1=FE_PHN83_n_33 A2=n<2> ZN=n_131 VSS=DVSS VDD=DVDD
Xp13233A5881__5107 CKND2D0 $PINS A1=FE_PHN76_b_col_os_5
+ A2=FE_PHN74_b_col_idx_temp_5 ZN=n_84 VSS=DVSS VDD=DVDD
Xp13166A__6260 NR2D0 $PINS A1=FE_PHN73_a_row_os_4 A2=b_row_idx<4> ZN=n_85
+ VSS=DVSS VDD=DVDD
Xp18091A5880__4319 CKND2D0 $PINS A1=FE_PHN54_a_row_os_3 A2=n<0> ZN=n_58
+ VSS=DVSS VDD=DVDD
Xp13175A__8428 CKND2D0 $PINS A1=FE_PHN75_b_col_os_4
+ A2=FE_PHN62_b_col_idx_temp_4 ZN=n_81 VSS=DVSS VDD=DVDD
Xp13310A__5526 CKND2D0 $PINS A1=FE_PHN60_a_row_os_6
+ A2=FE_PHN77_a_row_idx_temp_6 ZN=n_92 VSS=DVSS VDD=DVDD
Xp13312A__6783 CKND2D0 $PINS A1=FE_PHN67_b_col_os_6
+ A2=FE_PHN88_b_col_idx_temp_6 ZN=n_96 VSS=DVSS VDD=DVDD
Xp13216A__3680 NR2D0 $PINS A1=FE_PHN74_b_col_idx_temp_5 A2=FE_PHN76_b_col_os_5
+ ZN=n_83 VSS=DVSS VDD=DVDD
Xp13374A5883__1617 CKND2D0 $PINS A1=FE_PHN66_a_row_os_7 A2=a_row_idx_temp<7>
+ ZN=n_94 VSS=DVSS VDD=DVDD
Xp18165A__2802 NR2D0 $PINS A1=num_computation<1> A2=num_computation<0> ZN=n_62
+ VSS=DVSS VDD=DVDD
XFp8914A5895 CKND0 $PINS I=FE_RN_1 ZN=n_52 VSS=DVSS VDD=DVDD
Xp18107A5886__1705 CKND2D0 $PINS A1=FE_PHN53_b_col_os_3 A2=k<0> ZN=n_64
+ VSS=DVSS VDD=DVDD
Xp13177A__5122 CKND2D0 $PINS A1=FE_PHN73_a_row_os_4
+ A2=FE_PHN56_a_row_idx_temp_4 ZN=n_86 VSS=DVSS VDD=DVDD
Xp13167A5882__8246 NR2D0 $PINS A1=FE_PHN75_b_col_os_4
+ A2=FE_PHN62_b_col_idx_temp_4 ZN=n_82 VSS=DVSS VDD=DVDD
Xp13233A__7098 CKND2D0 $PINS A1=FE_PHN72_a_row_os_5
+ A2=FE_PHN78_a_row_idx_temp_5 ZN=n_80 VSS=DVSS VDD=DVDD
Xp13374A__6131 CKND2D0 $PINS A1=b_col_os<7> A2=FE_PHN58_b_col_idx_temp_7
+ ZN=n_98 VSS=DVSS VDD=DVDD
Xp13216A5884__1881 NR2D0 $PINS A1=b_row_idx<5> A2=FE_PHN72_a_row_os_5 ZN=n_79
+ VSS=DVSS VDD=DVDD
Xp18432A__5115 CKND2D0 $PINS A1=FE_PHN62_b_col_idx_temp_4
+ A2=FE_PHN52_b_col_idx_temp_3 ZN=n_276 VSS=DVSS VDD=DVDD
Xp18275A5876__7482 CKND2D0 $PINS A1=FE_PHN44_num_computated_0
+ A2=num_computated<1> ZN=n_78 VSS=DVSS VDD=DVDD
Xp13133A__4733 CKND2D0 $PINS A1=FE_PHN54_a_row_os_3 A2=b_row_idx<3> ZN=n_121
+ VSS=DVSS VDD=DVDD
Xp13132A__6161 CKND2D0 $PINS A1=FE_PHN53_b_col_os_3
+ A2=FE_PHN52_b_col_idx_temp_3 ZN=n_115 VSS=DVSS VDD=DVDD
XFp18482A CKND0 $PINS I=FE_PHN41_num_computated_4 ZN=n_206 VSS=DVSS VDD=DVDD
XFp18374A CKND0 $PINS I=FE_PHN44_num_computated_0 ZN=n_3 VSS=DVSS VDD=DVDD
XFp18108A CKND0 $PINS I=num_computation<0> ZN=n_1 VSS=DVSS VDD=DVDD
XFp18660A CKND0 $PINS I=FE_PHN40_rstn ZN=n_263 VSS=DVSS VDD=DVDD
XFp18408A CKND0 $PINS I=FE_PHN42_num_computated_2 ZN=n_171 VSS=DVSS VDD=DVDD
XFp18190A CKND0 $PINS I=num_computation<3> ZN=n_109 VSS=DVSS VDD=DVDD
Xg2 XOR3D0 $PINS A1=n_360 A2=b_row_idx<8> A3=a_row_os<8> Z=FE_OFN30_a_row_idx_8
+ VSS=DVSS VDD=DVDD
Xg3 IOA21D0 $PINS A1=n_232 A2=n_95 B=n_94 ZN=n_360 VSS=DVSS VDD=DVDD
Xg5971 CKXOR2D0 $PINS A1=n_220 A2=b_row_idx<6> Z=n_362 VSS=DVSS VDD=DVDD
Xg5972 CKXOR2D0 $PINS A1=n_185 A2=b_row_idx<5> Z=n_363 VSS=DVSS VDD=DVDD
Xg5973 MUX2ND0 $PINS I0=n_364 I1=FE_PHN49_a_row_idx_temp_3 S=b_row_idx<4>
+ ZN=n_365 VSS=DVSS VDD=DVDD
Xg5974 CKND0 $PINS I=n_169 ZN=n_364 VSS=DVSS VDD=DVDD
Xg5975 XNR2D0 $PINS A1=n_149 A2=n_67 ZN=n_366 VSS=DVSS VDD=DVDD
Xg5976 XNR2D0 $PINS A1=n_68 A2=k<6> ZN=n_367 VSS=DVSS VDD=DVDD
Xg5977 CKXOR2D0 $PINS A1=n_113 A2=u_ac_i<6> Z=n_368 VSS=DVSS VDD=DVDD
Xg5978 XNR2D0 $PINS A1=FE_PHN48_u_ac_i_3 A2=m<0> ZN=n_369 VSS=DVSS VDD=DVDD
Xdrc_bufs INVD12 $PINS I=FE_PHN55_n_2 ZN=b_row_idx<3> VSS=DVSS VDD=DVDD
Xdrc_bufs5988 INVD12 $PINS I=FE_PHN84_n_5 ZN=b_row_idx<7> VSS=DVSS VDD=DVDD
Xdrc_bufs5996 INVD12 $PINS I=FE_PHN50_n_7 ZN=a_col_idx<3> VSS=DVSS VDD=DVDD
Xdrc_bufs6005 CKND12 $PINS I=FE_PHN82_n_0 ZN=b_row_idx<4> VSS=DVSS VDD=DVDD
Xdrc_bufs6015 INVD12 $PINS I=FE_PHN68_n_11 ZN=a_col_idx<4> VSS=DVSS VDD=DVDD
Xdrc_bufs6023 INVD12 $PINS I=FE_PHN85_n_29 ZN=b_row_idx<6> VSS=DVSS VDD=DVDD
Xdrc_bufs6032 INVD12 $PINS I=FE_PHN83_n_33 ZN=b_row_idx<5> VSS=DVSS VDD=DVDD
Xdrc_bufs6042 INVD12 $PINS I=FE_PHN65_n_9 ZN=a_col_idx<5> VSS=DVSS VDD=DVDD
Xdrc_bufs6048 INVD12 $PINS I=FE_PHN81_n_4 ZN=b_row_idx<8> VSS=DVSS VDD=DVDD
Xdrc_bufs6054 INVD12 $PINS I=FE_PHN70_n_6 ZN=a_col_idx<7> VSS=DVSS VDD=DVDD
Xdrc_bufs6060 INVD12 $PINS I=FE_PHN63_n_16 ZN=a_col_idx<6> VSS=DVSS VDD=DVDD
Xdrc_bufs6065 INVD12 $PINS I=FE_PHN59_n_10 ZN=a_col_idx<8> VSS=DVSS VDD=DVDD
Xb_col_os_reg[6] EDFKCND1 $PINS CN=FE_PHN40_rstn CP=CTS_4 D=FE_PHN91_n_260
+ E=n_336 Q=b_col_os<6> QN=n_48 VSS=DVSS VDD=DVDD
Xlast_data_read_reg DFXD1 $PINS CP=CTS_1 DA=FE_PHN40_rstn
+ DB=FE_PHN87_last_data_read Q=last_data_read QN=n_30 SA=n_285 VSS=DVSS VDD=DVDD
Xb_col_os_reg[7] EDFKCND1 $PINS CN=FE_PHN40_rstn CP=CTS_1 D=FE_PHN90_n_266
+ E=n_336 Q=b_col_os<7> QN=n_25 VSS=DVSS VDD=DVDD
Xu_ac_j_reg[6] DFXD1 $PINS CP=CTS_4 DA=n_321 DB=FE_PHN126_n_290
+ Q=b_col_idx_temp<6> QN=n_89 SA=FE_PHN88_b_col_idx_temp_6 VSS=DVSS VDD=DVDD
Xa_row_os_reg[7] EDFKCND1 $PINS CN=FE_PHN40_rstn CP=CTS_4 D=FE_PHN100_n_265
+ E=n_336 Q=a_row_os<7> QN=n_19 VSS=DVSS VDD=DVDD
Xa_row_os_reg[6] EDFKCND1 $PINS CN=FE_PHN40_rstn CP=CTS_3 D=FE_PHN98_n_258
+ E=n_336 Q=a_row_os<6> QN=n_8 VSS=DVSS VDD=DVDD
Xu_ac_j_reg[3] DFXD1 $PINS CP=CTS_4 DA=n_275 DB=n_277 Q=b_col_idx_temp<3>
+ QN=n_60 SA=FE_PHN52_b_col_idx_temp_3 VSS=DVSS VDD=DVDD
Xu_ac_j_reg[8] DFD1 $PINS CP=CTS_1 D=FE_PHN127_n_346 Q=b_col_idx_temp<8>
+ QN=n_57 VSS=DVSS VDD=DVDD
Xu_ac_j_reg[4] DFD1 $PINS CP=CTS_4 D=n_272 Q=b_col_idx_temp<4> QN=n_75 VSS=DVSS
+ VDD=DVDD
Xu_ac_j_reg[7] DFD1 $PINS CP=CTS_1 D=n_345 Q=b_col_idx_temp<7> QN=n_90 VSS=DVSS
+ VDD=DVDD
Xu_ac_j_reg[5] DFD1 $PINS CP=CTS_4 D=FE_PHN117_n_317 Q=b_col_idx_temp<5>
+ QN=n_267 VSS=DVSS VDD=DVDD
Xu_ac_z_reg[3] DFD1 $PINS CP=CTS_4 D=n_335 Q=a_row_idx_temp<3> QN=n_2 VSS=DVSS
+ VDD=DVDD
Xu_ac_z_reg[7] DFD1 $PINS CP=CTS_4 D=FE_PHN115_n_339 Q=a_row_idx_temp<7> QN=n_5
+ VSS=DVSS VDD=DVDD
Xu_ac_i_reg[3] DFD1 $PINS CP=CTS_3 D=FE_PHN113_n_308 Q=u_ac_i<3> QN=n_7
+ VSS=DVSS VDD=DVDD
Xu_ac_z_reg[4] DFD1 $PINS CP=CTS_3 D=n_331 Q=a_row_idx_temp<4> QN=n_0 VSS=DVSS
+ VDD=DVDD
Xu_ac_i_reg[4] DFD1 $PINS CP=CTS_3 D=FE_PHN106_n_340 Q=u_ac_i<4> QN=n_11
+ VSS=DVSS VDD=DVDD
Xu_ac_z_reg[6] DFD1 $PINS CP=CTS_3 D=n_287 Q=a_row_idx_temp<6> QN=n_29 VSS=DVSS
+ VDD=DVDD
Xu_ac_z_reg[5] DFD1 $PINS CP=CTS_3 D=n_286 Q=a_row_idx_temp<5> QN=n_33 VSS=DVSS
+ VDD=DVDD
Xu_ac_i_reg[5] DFD1 $PINS CP=CTS_3 D=FE_PHN112_n_326 Q=u_ac_i<5> QN=n_9
+ VSS=DVSS VDD=DVDD
Xu_ac_z_reg[8] DFD1 $PINS CP=CTS_4 D=FE_PHN109_n_342 Q=a_row_idx_temp<8> QN=n_4
+ VSS=DVSS VDD=DVDD
Xu_ac_i_reg[7] DFD1 $PINS CP=CTS_3 D=FE_PHN111_n_324 Q=u_ac_i<7> QN=n_6
+ VSS=DVSS VDD=DVDD
Xu_ac_i_reg[6] DFD1 $PINS CP=CTS_3 D=FE_PHN108_n_292 Q=u_ac_i<6> QN=n_16
+ VSS=DVSS VDD=DVDD
Xu_ac_i_reg[8] DFD1 $PINS CP=CTS_3 D=FE_PHN110_n_333 Q=u_ac_i<8> QN=n_10
+ VSS=DVSS VDD=DVDD
Xg6120 CKAN2D0 $PINS A1=n_121 A2=n_107 Z=n_466 VSS=DVSS VDD=DVDD
Xg6121 IND2D0 $PINS A1=FE_PHN54_a_row_os_3 B1=FE_PHN55_n_2 ZN=n_467 VSS=DVSS
+ VDD=DVDD
Xg6122 IND2D0 $PINS A1=FE_PHN53_b_col_os_3 B1=FE_PHN64_n_60 ZN=n_468 VSS=DVSS
+ VDD=DVDD
XFILLER_T_1_407 DCAP4 $PINS VSS=DVSS VDD=DVDD
XFILLER_T_1_405 DCAP8 $PINS VSS=DVSS VDD=DVDD
XFILLER_T_1_400 DCAP4 $PINS VSS=DVSS VDD=DVDD
XFILLER_T_1_398 DCAP4 $PINS VSS=DVSS VDD=DVDD
XFILLER_T_1_396 DCAP4 $PINS VSS=DVSS VDD=DVDD
XFILLER_T_1_393 DCAP4 $PINS VSS=DVSS VDD=DVDD
XFILLER_T_1_391 DCAP4 $PINS VSS=DVSS VDD=DVDD
XFILLER_T_1_384 DCAP4 $PINS VSS=DVSS VDD=DVDD
XFILLER_T_1_378 DCAP4 $PINS VSS=DVSS VDD=DVDD
XFILLER_T_1_366 DCAP4 $PINS VSS=DVSS VDD=DVDD
XFILLER_T_1_360 DCAP4 $PINS VSS=DVSS VDD=DVDD
XFILLER_T_1_349 DCAP4 $PINS VSS=DVSS VDD=DVDD
XFILLER_T_1_348 DCAP8 $PINS VSS=DVSS VDD=DVDD
XFILLER_T_1_344 DCAP8 $PINS VSS=DVSS VDD=DVDD
XFILLER_T_1_342 DCAP4 $PINS VSS=DVSS VDD=DVDD
XFILLER_T_1_326 DCAP4 $PINS VSS=DVSS VDD=DVDD
XFILLER_T_1_325 DCAP4 $PINS VSS=DVSS VDD=DVDD
XFILLER_T_1_324 DCAP8 $PINS VSS=DVSS VDD=DVDD
XFILLER_T_1_320 DCAP8 $PINS VSS=DVSS VDD=DVDD
XFILLER_T_1_318 DCAP4 $PINS VSS=DVSS VDD=DVDD
XFILLER_T_1_313 DCAP4 $PINS VSS=DVSS VDD=DVDD
XFILLER_T_1_312 DCAP4 $PINS VSS=DVSS VDD=DVDD
XFILLER_T_1_310 DCAP4 $PINS VSS=DVSS VDD=DVDD
XFILLER_T_1_306 DCAP4 $PINS VSS=DVSS VDD=DVDD
XFILLER_T_1_298 DCAP4 $PINS VSS=DVSS VDD=DVDD
XFILLER_T_1_280 DCAP4 $PINS VSS=DVSS VDD=DVDD
XFILLER_T_1_274 DCAP8 $PINS VSS=DVSS VDD=DVDD
XFILLER_T_1_273 DCAP4 $PINS VSS=DVSS VDD=DVDD
XFILLER_T_1_270 DCAP4 $PINS VSS=DVSS VDD=DVDD
XFILLER_T_1_260 DCAP4 $PINS VSS=DVSS VDD=DVDD
XFILLER_T_1_259 DCAP4 $PINS VSS=DVSS VDD=DVDD
XFILLER_T_1_256 DCAP4 $PINS VSS=DVSS VDD=DVDD
XFILLER_T_1_249 DCAP4 $PINS VSS=DVSS VDD=DVDD
XFILLER_T_1_248 DCAP4 $PINS VSS=DVSS VDD=DVDD
XFILLER_T_1_246 DCAP4 $PINS VSS=DVSS VDD=DVDD
XFILLER_T_1_245 DCAP8 $PINS VSS=DVSS VDD=DVDD
XFILLER_T_1_243 DCAP8 $PINS VSS=DVSS VDD=DVDD
XFILLER_T_1_238 DCAP4 $PINS VSS=DVSS VDD=DVDD
XFILLER_T_1_236 DCAP4 $PINS VSS=DVSS VDD=DVDD
XFILLER_T_1_225 DCAP4 $PINS VSS=DVSS VDD=DVDD
XFILLER_T_1_223 DCAP4 $PINS VSS=DVSS VDD=DVDD
XFILLER_T_1_220 DCAP4 $PINS VSS=DVSS VDD=DVDD
XFILLER_T_1_204 DCAP4 $PINS VSS=DVSS VDD=DVDD
XFILLER_T_1_194 DCAP8 $PINS VSS=DVSS VDD=DVDD
XFILLER_T_1_190 DCAP8 $PINS VSS=DVSS VDD=DVDD
XFILLER_T_1_187 DCAP8 $PINS VSS=DVSS VDD=DVDD
XFILLER_T_1_183 DCAP4 $PINS VSS=DVSS VDD=DVDD
XFILLER_T_1_178 DCAP4 $PINS VSS=DVSS VDD=DVDD
XFILLER_T_1_176 DCAP4 $PINS VSS=DVSS VDD=DVDD
XFILLER_T_1_171 DCAP8 $PINS VSS=DVSS VDD=DVDD
XFILLER_T_1_169 DCAP4 $PINS VSS=DVSS VDD=DVDD
XFILLER_T_1_166 DCAP4 $PINS VSS=DVSS VDD=DVDD
XFILLER_T_1_154 DCAP4 $PINS VSS=DVSS VDD=DVDD
XFILLER_T_1_138 DCAP8 $PINS VSS=DVSS VDD=DVDD
XFILLER_T_1_136 DCAP4 $PINS VSS=DVSS VDD=DVDD
XFILLER_T_1_131 DCAP4 $PINS VSS=DVSS VDD=DVDD
XFILLER_T_1_127 DCAP4 $PINS VSS=DVSS VDD=DVDD
XFILLER_T_1_112 DCAP4 $PINS VSS=DVSS VDD=DVDD
XFILLER_T_1_94 DCAP4 $PINS VSS=DVSS VDD=DVDD
XFILLER_T_1_89 DCAP8 $PINS VSS=DVSS VDD=DVDD
XFILLER_T_1_80 DCAP4 $PINS VSS=DVSS VDD=DVDD
XFILLER_T_1_77 DCAP4 $PINS VSS=DVSS VDD=DVDD
XFILLER_T_1_72 DCAP4 $PINS VSS=DVSS VDD=DVDD
XFILLER_T_1_71 DCAP4 $PINS VSS=DVSS VDD=DVDD
XFILLER_T_1_67 DCAP4 $PINS VSS=DVSS VDD=DVDD
XFILLER_T_1_65 DCAP4 $PINS VSS=DVSS VDD=DVDD
XFILLER_T_1_62 DCAP4 $PINS VSS=DVSS VDD=DVDD
XFILLER_T_1_60 DCAP4 $PINS VSS=DVSS VDD=DVDD
XFILLER_T_1_52 DCAP8 $PINS VSS=DVSS VDD=DVDD
XFILLER_T_1_50 DCAP4 $PINS VSS=DVSS VDD=DVDD
XFILLER_T_1_48 DCAP8 $PINS VSS=DVSS VDD=DVDD
XFILLER_T_1_44 DCAP4 $PINS VSS=DVSS VDD=DVDD
XFILLER_T_1_34 DCAP4 $PINS VSS=DVSS VDD=DVDD
XFILLER_T_1_22 DCAP4 $PINS VSS=DVSS VDD=DVDD
XFILLER_T_1_17 DCAP8 $PINS VSS=DVSS VDD=DVDD
XFILLER_T_1_9 DCAP4 $PINS VSS=DVSS VDD=DVDD
XFILLER_T_1_2 DCAP4 $PINS VSS=DVSS VDD=DVDD
XFILLER_T_1_1 DCAP4 $PINS VSS=DVSS VDD=DVDD
.ENDS
.GLOBAL DVDD
.GLOBAL DVSS
