$ Spice netlist generated by v2lvs
$ v2024.3_25.13    Thu Aug 1 18:56:55 PDT 2024
.INCLUDE "/courses/ee6350/pdk2023/T-N65-CM-SP-018-K3_MOM/digital/Back_End/spice/tcbn65gplus_200a/tcbn65gplus_200a.spi"
*.BUSDELIMITER <

.SUBCKT bus_slave_c BUS_CLK BUS_RST_N CHC_START CHC_RD CHC_RDATA<7>
+ CHC_RDATA<6> CHC_RDATA<5> CHC_RDATA<4> CHC_RDATA<3> CHC_RDATA<2> CHC_RDATA<1>
+ CHC_RDATA<0> sram_c_re sram_c_addr<11> sram_c_addr<10> sram_c_addr<9>
+ sram_c_addr<8> sram_c_addr<7> sram_c_addr<6> sram_c_addr<5> sram_c_addr<4>
+ sram_c_addr<3> sram_c_addr<2> sram_c_addr<1> sram_c_addr<0> sram_c_dout<7>
+ sram_c_dout<6> sram_c_dout<5> sram_c_dout<4> sram_c_dout<3> sram_c_dout<2>
+ sram_c_dout<1> sram_c_dout<0> debug_cnt_c<11> debug_cnt_c<10> debug_cnt_c<9>
+ debug_cnt_c<8> debug_cnt_c<7> debug_cnt_c<6> debug_cnt_c<5> debug_cnt_c<4>
+ debug_cnt_c<3> debug_cnt_c<2> debug_cnt_c<1> debug_cnt_c<0> DVDD DVSS
*.CONNECT FE_RN_7 sram_c_addr<0>
*.CONNECT debug_cnt_c<1> FE_RN_8
*.CONNECT debug_cnt_c<2> FE_RN_6
*.CONNECT debug_cnt_c<4> FE_RN_5
*.CONNECT debug_cnt_c<5> FE_RN_4
*.CONNECT debug_cnt_c<8> FE_RN_3
*.CONNECT debug_cnt_c<9> FE_RN_2
*.CONNECT debug_cnt_c<11> FE_RN_1
*.CONNECT CHC_RDATA<0> sram_c_dout<0>
*.CONNECT CHC_RDATA<1> sram_c_dout<1>
*.CONNECT CHC_RDATA<2> sram_c_dout<2>
*.CONNECT CHC_RDATA<3> sram_c_dout<3>
*.CONNECT CHC_RDATA<4> sram_c_dout<4>
*.CONNECT CHC_RDATA<5> sram_c_dout<5>
*.CONNECT CHC_RDATA<6> sram_c_dout<6>
*.CONNECT CHC_RDATA<7> sram_c_dout<7>
XFE_PDC36_n_58 CKBD0 $PINS I=n_58 Z=FE_PDN36_n_58 VSS=DVSS VDD=DVDD
XFE_PDC35_n_65 CKBD0 $PINS I=n_65 Z=FE_PDN35_n_65 VSS=DVSS VDD=DVDD
XFE_PHC80_BUS_RST_N BUFFD1 $PINS I=BUS_RST_N Z=FE_PHN80_BUS_RST_N VSS=DVSS
+ VDD=DVDD
XFE_PHC79_FE_OFN12_debug_cnt_c_7 BUFFD1 $PINS I=FE_OFN12_debug_cnt_c_7
+ Z=FE_PHN79_FE_OFN12_debug_cnt_c_7 VSS=DVSS VDD=DVDD
XFE_PHC78_n_78 BUFFD1 $PINS I=n_78 Z=FE_PHN78_n_78 VSS=DVSS VDD=DVDD
XFE_PHC77_n_84 DEL2 $PINS I=n_84 Z=FE_PHN77_n_84 VSS=DVSS VDD=DVDD
XFE_PHC76_n_89 DEL2 $PINS I=n_89 Z=FE_PHN76_n_89 VSS=DVSS VDD=DVDD
XFE_PHC75_n_72 DEL1 $PINS I=FE_PHN75_n_72 Z=FE_PHN48_n_72 VSS=DVSS VDD=DVDD
XFE_PHC74_n_65 DEL1 $PINS I=FE_PDN35_n_65 Z=FE_PHN74_n_65 VSS=DVSS VDD=DVDD
XFE_PHC73_n_92 DEL1 $PINS I=n_92 Z=FE_PHN73_n_92 VSS=DVSS VDD=DVDD
XFE_PHC72_n_58 DEL1 $PINS I=FE_PDN36_n_58 Z=FE_PHN72_n_58 VSS=DVSS VDD=DVDD
XFE_PHC71_n_64 DEL1 $PINS I=n_64 Z=FE_PHN71_n_64 VSS=DVSS VDD=DVDD
XFE_PHC70_n_71 DEL1 $PINS I=n_71 Z=FE_PHN70_n_71 VSS=DVSS VDD=DVDD
XFE_PHC69_n_78 DEL1 $PINS I=FE_PHN78_n_78 Z=FE_PHN69_n_78 VSS=DVSS VDD=DVDD
XFE_PHC68_BUS_RST_N DEL0 $PINS I=FE_PHN80_BUS_RST_N Z=FE_PHN68_BUS_RST_N
+ VSS=DVSS VDD=DVDD
XFE_PHC67_FE_OFN32_debug_cnt_c_0 DEL1 $PINS I=FE_OFN32_debug_cnt_c_0
+ Z=FE_PHN67_FE_OFN32_debug_cnt_c_0 VSS=DVSS VDD=DVDD
XFE_PHC66_CHC_START DEL1 $PINS I=CHC_START Z=FE_PHN66_CHC_START VSS=DVSS
+ VDD=DVDD
XFE_PHC65_n_35 DEL1 $PINS I=n_35 Z=FE_PHN65_n_35 VSS=DVSS VDD=DVDD
XFE_PHC64_FE_OFN6_debug_cnt_c_9 DEL2 $PINS I=FE_PHN64_FE_OFN6_debug_cnt_c_9
+ Z=FE_OFN6_debug_cnt_c_9 VSS=DVSS VDD=DVDD
XFE_PHC63_CHC_RD DEL1 $PINS I=CHC_RD Z=FE_PHN63_CHC_RD VSS=DVSS VDD=DVDD
XFE_PHC62_FE_OFN12_debug_cnt_c_7 DEL1 $PINS I=FE_PHN79_FE_OFN12_debug_cnt_c_7
+ Z=FE_PHN62_FE_OFN12_debug_cnt_c_7 VSS=DVSS VDD=DVDD
XFE_PHC61_n_20 DEL1 $PINS I=FE_PHN61_n_20 Z=n_20 VSS=DVSS VDD=DVDD
XFE_PHC60_BUS_RST_N DEL1 $PINS I=FE_PHN68_BUS_RST_N Z=FE_PHN60_BUS_RST_N
+ VSS=DVSS VDD=DVDD
XFE_PHC59_BUS_RST_N DEL1 $PINS I=FE_PHN68_BUS_RST_N Z=FE_PHN59_BUS_RST_N
+ VSS=DVSS VDD=DVDD
XFE_PHC58_BUS_RST_N DEL1 $PINS I=FE_PHN68_BUS_RST_N Z=FE_PHN58_BUS_RST_N
+ VSS=DVSS VDD=DVDD
XFE_PHC57_BUS_RST_N DEL1 $PINS I=FE_PHN68_BUS_RST_N Z=FE_PHN57_BUS_RST_N
+ VSS=DVSS VDD=DVDD
XFE_PHC56_BUS_RST_N DEL1 $PINS I=FE_PHN68_BUS_RST_N Z=FE_PHN56_BUS_RST_N
+ VSS=DVSS VDD=DVDD
XFE_PHC55_BUS_RST_N DEL1 $PINS I=FE_PHN68_BUS_RST_N Z=FE_PHN55_BUS_RST_N
+ VSS=DVSS VDD=DVDD
XFE_PHC54_n_92 DEL1 $PINS I=FE_PHN73_n_92 Z=FE_PHN54_n_92 VSS=DVSS VDD=DVDD
XFE_PHC53_n_89 DEL1 $PINS I=FE_PHN76_n_89 Z=FE_PHN53_n_89 VSS=DVSS VDD=DVDD
XFE_PHC52_n_88 DEL1 $PINS I=n_88 Z=FE_PHN52_n_88 VSS=DVSS VDD=DVDD
XFE_PHC51_n_80 DEL1 $PINS I=n_80 Z=FE_PHN51_n_80 VSS=DVSS VDD=DVDD
XFE_PHC50_n_84 DEL1 $PINS I=FE_PHN77_n_84 Z=FE_PHN50_n_84 VSS=DVSS VDD=DVDD
XFE_PHC49_n_78 DEL1 $PINS I=FE_PHN69_n_78 Z=FE_PHN49_n_78 VSS=DVSS VDD=DVDD
XFE_PHC48_n_72 DEL1 $PINS I=n_72 Z=FE_PHN75_n_72 VSS=DVSS VDD=DVDD
XFE_PHC47_n_70 DEL1 $PINS I=n_70 Z=FE_PHN47_n_70 VSS=DVSS VDD=DVDD
XFE_PHC46_n_71 DEL1 $PINS I=FE_PHN70_n_71 Z=FE_PHN46_n_71 VSS=DVSS VDD=DVDD
XFE_PHC45_n_67 DEL1 $PINS I=n_67 Z=FE_PHN45_n_67 VSS=DVSS VDD=DVDD
XFE_PHC44_n_64 DEL1 $PINS I=FE_PHN71_n_64 Z=FE_PHN44_n_64 VSS=DVSS VDD=DVDD
XFE_PHC43_BUS_RST_N DEL1 $PINS I=FE_PHN68_BUS_RST_N Z=FE_PHN43_BUS_RST_N
+ VSS=DVSS VDD=DVDD
XFE_PHC42_CHC_RD DEL1 $PINS I=FE_PHN63_CHC_RD Z=FE_PHN42_CHC_RD VSS=DVSS
+ VDD=DVDD
XFE_PHC41_FE_OFN24_debug_cnt_c_3 DEL1 $PINS I=FE_OFN24_debug_cnt_c_3
+ Z=FE_PHN41_FE_OFN24_debug_cnt_c_3 VSS=DVSS VDD=DVDD
XFE_PHC40_FE_OFN32_debug_cnt_c_0 DEL1 $PINS I=FE_PHN67_FE_OFN32_debug_cnt_c_0
+ Z=FE_PHN40_FE_OFN32_debug_cnt_c_0 VSS=DVSS VDD=DVDD
XFE_PHC39_FE_OFN30_debug_cnt_c_1 DEL1 $PINS I=FE_OFN30_debug_cnt_c_1
+ Z=FE_PHN39_FE_OFN30_debug_cnt_c_1 VSS=DVSS VDD=DVDD
XFE_PHC38_n_35 DEL1 $PINS I=FE_PHN65_n_35 Z=FE_PHN38_n_35 VSS=DVSS VDD=DVDD
XFE_PHC37_n_0 DEL1 $PINS I=n_0 Z=FE_PHN37_n_0 VSS=DVSS VDD=DVDD
XFE_PHC36_n_6 DEL1 $PINS I=n_6 Z=FE_PHN36_n_6 VSS=DVSS VDD=DVDD
XFE_PHC35_CHC_START DEL1 $PINS I=FE_PHN66_CHC_START Z=FE_PHN35_CHC_START
+ VSS=DVSS VDD=DVDD
XCTS_ccl_a_inv_00001 CKND6 $PINS I=CTS_2 ZN=CTS_1 VSS=DVSS VDD=DVDD
XCTS_cmf_inv_00047 CKND1 $PINS I=BUS_CLK ZN=CTS_2 VSS=DVSS VDD=DVDD
XFE_OFC34_debug_cnt_c_1 BUFFD12 $PINS I=debug_cnt_c<1> Z=sram_c_addr<1>
+ VSS=DVSS VDD=DVDD
XFE_OFC33_debug_cnt_c_0 BUFFD12 $PINS I=FE_RN_7 Z=debug_cnt_c<0> VSS=DVSS
+ VDD=DVDD
XFE_OFC32_debug_cnt_c_0 BUFFD12 $PINS I=FE_PHN40_FE_OFN32_debug_cnt_c_0
+ Z=sram_c_addr<0> VSS=DVSS VDD=DVDD
XFE_OFC30_debug_cnt_c_1 CKBD12 $PINS I=FE_PHN39_FE_OFN30_debug_cnt_c_1
+ Z=FE_RN_8 VSS=DVSS VDD=DVDD
XFE_OFC29_debug_cnt_c_2 INVD12 $PINS I=FE_OFN28_debug_cnt_c_2 ZN=sram_c_addr<2>
+ VSS=DVSS VDD=DVDD
XFE_OFC28_debug_cnt_c_2 INVD12 $PINS I=FE_OFN28_debug_cnt_c_2 ZN=FE_RN_6
+ VSS=DVSS VDD=DVDD
XFE_OFC27_debug_cnt_c_2 INVD1 $PINS I=FE_OFN27_debug_cnt_c_2
+ ZN=FE_OFN28_debug_cnt_c_2 VSS=DVSS VDD=DVDD
XFE_OFC26_debug_cnt_c_3 INVD12 $PINS I=FE_OFN25_debug_cnt_c_3 ZN=debug_cnt_c<3>
+ VSS=DVSS VDD=DVDD
XFE_OFC25_debug_cnt_c_3 INVD12 $PINS I=FE_OFN25_debug_cnt_c_3 ZN=sram_c_addr<3>
+ VSS=DVSS VDD=DVDD
XFE_OFC24_debug_cnt_c_3 INVD1 $PINS I=FE_PHN41_FE_OFN24_debug_cnt_c_3
+ ZN=FE_OFN25_debug_cnt_c_3 VSS=DVSS VDD=DVDD
XFE_OFC23_debug_cnt_c_4 INVD12 $PINS I=FE_OFN22_debug_cnt_c_4 ZN=sram_c_addr<4>
+ VSS=DVSS VDD=DVDD
XFE_OFC22_debug_cnt_c_4 INVD12 $PINS I=FE_OFN22_debug_cnt_c_4 ZN=FE_RN_5
+ VSS=DVSS VDD=DVDD
XFE_OFC21_debug_cnt_c_4 INVD1 $PINS I=FE_OFN21_debug_cnt_c_4
+ ZN=FE_OFN22_debug_cnt_c_4 VSS=DVSS VDD=DVDD
XFE_OFC20_debug_cnt_c_5 INVD12 $PINS I=FE_OFN19_debug_cnt_c_5 ZN=sram_c_addr<5>
+ VSS=DVSS VDD=DVDD
XFE_OFC19_debug_cnt_c_5 INVD12 $PINS I=FE_OFN19_debug_cnt_c_5 ZN=FE_RN_4
+ VSS=DVSS VDD=DVDD
XFE_OFC18_debug_cnt_c_5 INVD1 $PINS I=FE_OFN18_debug_cnt_c_5
+ ZN=FE_OFN19_debug_cnt_c_5 VSS=DVSS VDD=DVDD
XFE_OFC17_debug_cnt_c_6 INVD12 $PINS I=FE_OFN16_debug_cnt_c_6 ZN=debug_cnt_c<6>
+ VSS=DVSS VDD=DVDD
XFE_OFC16_debug_cnt_c_6 INVD12 $PINS I=FE_OFN16_debug_cnt_c_6 ZN=sram_c_addr<6>
+ VSS=DVSS VDD=DVDD
XFE_OFC15_debug_cnt_c_6 INVD1 $PINS I=FE_OFN15_debug_cnt_c_6
+ ZN=FE_OFN16_debug_cnt_c_6 VSS=DVSS VDD=DVDD
XFE_OFC14_debug_cnt_c_7 INVD12 $PINS I=FE_OFN13_debug_cnt_c_7 ZN=debug_cnt_c<7>
+ VSS=DVSS VDD=DVDD
XFE_OFC13_debug_cnt_c_7 INVD12 $PINS I=FE_OFN13_debug_cnt_c_7 ZN=sram_c_addr<7>
+ VSS=DVSS VDD=DVDD
XFE_OFC12_debug_cnt_c_7 INVD1 $PINS I=FE_PHN62_FE_OFN12_debug_cnt_c_7
+ ZN=FE_OFN13_debug_cnt_c_7 VSS=DVSS VDD=DVDD
XFE_OFC11_debug_cnt_c_8 INVD12 $PINS I=FE_OFN10_debug_cnt_c_8 ZN=sram_c_addr<8>
+ VSS=DVSS VDD=DVDD
XFE_OFC10_debug_cnt_c_8 INVD12 $PINS I=FE_OFN10_debug_cnt_c_8 ZN=FE_RN_3
+ VSS=DVSS VDD=DVDD
XFE_OFC9_debug_cnt_c_8 INVD1 $PINS I=FE_OFN9_debug_cnt_c_8
+ ZN=FE_OFN10_debug_cnt_c_8 VSS=DVSS VDD=DVDD
XFE_OFC8_debug_cnt_c_9 INVD12 $PINS I=FE_OFN7_debug_cnt_c_9 ZN=sram_c_addr<9>
+ VSS=DVSS VDD=DVDD
XFE_OFC7_debug_cnt_c_9 INVD12 $PINS I=FE_OFN7_debug_cnt_c_9 ZN=FE_RN_2 VSS=DVSS
+ VDD=DVDD
XFE_OFC6_debug_cnt_c_9 INVD1 $PINS I=FE_OFN6_debug_cnt_c_9
+ ZN=FE_OFN7_debug_cnt_c_9 VSS=DVSS VDD=DVDD
XFE_OFC5_debug_cnt_c_10 INVD12 $PINS I=FE_OFN4_debug_cnt_c_10
+ ZN=debug_cnt_c<10> VSS=DVSS VDD=DVDD
XFE_OFC4_debug_cnt_c_10 INVD12 $PINS I=FE_OFN4_debug_cnt_c_10
+ ZN=sram_c_addr<10> VSS=DVSS VDD=DVDD
XFE_OFC3_debug_cnt_c_10 INVD1 $PINS I=FE_OFN3_debug_cnt_c_10
+ ZN=FE_OFN4_debug_cnt_c_10 VSS=DVSS VDD=DVDD
XFE_OFC2_debug_cnt_c_11 BUFFD12 $PINS I=debug_cnt_c<11> Z=sram_c_addr<11>
+ VSS=DVSS VDD=DVDD
XFE_OFC1_debug_cnt_c_11 BUFFD12 $PINS I=FE_OFN1_debug_cnt_c_11 Z=FE_RN_1
+ VSS=DVSS VDD=DVDD
Xcnt_c_reg[11] DFNCND1 $PINS CDN=FE_PHN57_BUS_RST_N CPN=CTS_1 D=FE_PHN54_n_92
+ Q=FE_OFN1_debug_cnt_c_11 QN=UNCONNECTED VSS=DVSS VDD=DVDD
Xp95792A__2398 NR2D0 $PINS A1=n_106 A2=FE_PHN35_CHC_START ZN=n_92 VSS=DVSS
+ VDD=DVDD
Xcnt_c_reg[10] DFNCND1 $PINS CDN=FE_PHN59_BUS_RST_N CPN=CTS_1 D=FE_PHN53_n_89
+ Q=FE_OFN3_debug_cnt_c_10 QN=n_18 VSS=DVSS VDD=DVDD
Xp95821A__6260 NR2D0 $PINS A1=n_87 A2=FE_PHN35_CHC_START ZN=n_89 VSS=DVSS
+ VDD=DVDD
Xcnt_c_reg[9] DFNCND1 $PINS CDN=FE_PHN60_BUS_RST_N CPN=CTS_1 D=FE_PHN52_n_88
+ Q=FE_PHN64_FE_OFN6_debug_cnt_c_9 QN=UNCONNECTED0 VSS=DVSS VDD=DVDD
Xcnt_c_reg[8] DFNCND1 $PINS CDN=FE_PHN58_BUS_RST_N CPN=CTS_1 D=FE_PHN50_n_84
+ Q=FE_OFN9_debug_cnt_c_8 QN=FE_PHN61_n_20 VSS=DVSS VDD=DVDD
Xp95850A__4319 AOI21D0 $PINS A1=n_82 A2=n_55 B=FE_PHN35_CHC_START ZN=n_88
+ VSS=DVSS VDD=DVDD
Xp95810A__8428 AOI32D0 $PINS A1=n_85 A2=n_79 A3=sram_c_re
+ B1=FE_OFN3_debug_cnt_c_10 B2=FE_PHN38_n_35 ZN=n_87 VSS=DVSS VDD=DVDD
Xp95771A__5526 MOAI22D0 $PINS A1=n_85 A2=FE_RN_1 B1=n_85 B2=FE_RN_1 ZN=n_86
+ VSS=DVSS VDD=DVDD
Xp95879A__6783 NR2D0 $PINS A1=n_107 A2=FE_PHN35_CHC_START ZN=n_84 VSS=DVSS
+ VDD=DVDD
Xcnt_c_reg[7] DFNCND1 $PINS CDN=FE_PHN55_BUS_RST_N CPN=CTS_1 D=FE_PHN51_n_80
+ Q=FE_OFN12_debug_cnt_c_7 QN=UNCONNECTED1 VSS=DVSS VDD=DVDD
Xp95856A306__1617 OAI211D0 $PINS A1=FE_OFN6_debug_cnt_c_9 A2=n_76 B=n_81
+ C=sram_c_re ZN=n_82 VSS=DVSS VDD=DVDD
Xcnt_c_reg[6] DFNCND1 $PINS CDN=FE_PHN56_BUS_RST_N CPN=CTS_1 D=FE_PHN49_n_78
+ Q=FE_OFN15_debug_cnt_c_6 QN=n_3 VSS=DVSS VDD=DVDD
Xp95752A__2802 OR2D0 $PINS A1=n_81 A2=n_18 Z=n_85 VSS=DVSS VDD=DVDD
Xp95906A__1705 AOI21D0 $PINS A1=n_75 A2=n_54 B=FE_PHN35_CHC_START ZN=n_80
+ VSS=DVSS VDD=DVDD
Xp95856A__5122 CKND2D0 $PINS A1=n_81 A2=n_18 ZN=n_79 VSS=DVSS VDD=DVDD
Xp95934A__8246 NR2D0 $PINS A1=n_108 A2=FE_PHN35_CHC_START ZN=n_78 VSS=DVSS
+ VDD=DVDD
Xcnt_c_reg[5] DFNCND1 $PINS CDN=FE_PHN43_BUS_RST_N CPN=CTS_1 D=FE_PHN48_n_72
+ Q=FE_OFN18_debug_cnt_c_5 QN=UNCONNECTED2 VSS=DVSS VDD=DVDD
Xp95858A__7098 AOI21D0 $PINS A1=n_74 A2=n_20 B=n_76 ZN=n_77 VSS=DVSS VDD=DVDD
Xp95742A__6131 CKND2D0 $PINS A1=n_76 A2=FE_OFN6_debug_cnt_c_9 ZN=n_81 VSS=DVSS
+ VDD=DVDD
Xcnt_c_reg[4] DFNCND1 $PINS CDN=FE_PHN43_BUS_RST_N CPN=CTS_1 D=FE_PHN46_n_71
+ Q=FE_OFN21_debug_cnt_c_4 QN=n_0 VSS=DVSS VDD=DVDD
Xp95912A__1881 OAI211D0 $PINS A1=FE_PHN62_FE_OFN12_debug_cnt_c_7
+ A2=FE_PHN47_n_70 B=n_74 C=sram_c_re ZN=n_75 VSS=DVSS VDD=DVDD
Xp95962A__7482 AOI21D0 $PINS A1=n_68 A2=n_47 B=FE_PHN35_CHC_START ZN=n_72
+ VSS=DVSS VDD=DVDD
Xp95716A__4733 NR2D0 $PINS A1=n_74 A2=n_20 ZN=n_76 VSS=DVSS VDD=DVDD
Xp95991A__6161 NR2XD0 $PINS A1=n_109 A2=FE_PHN35_CHC_START ZN=n_71 VSS=DVSS
+ VDD=DVDD
Xp95705A__9315 CKND2D0 $PINS A1=FE_PHN47_n_70
+ A2=FE_PHN62_FE_OFN12_debug_cnt_c_7 ZN=n_74 VSS=DVSS VDD=DVDD
Xp95914A__9945 AOI21D0 $PINS A1=FE_PHN45_n_67 A2=n_3 B=FE_PHN47_n_70 ZN=n_69
+ VSS=DVSS VDD=DVDD
Xcnt_c_reg[3] DFNCND1 $PINS CDN=FE_PHN43_BUS_RST_N CPN=CTS_1 D=FE_PHN74_n_65
+ Q=FE_OFN24_debug_cnt_c_3 QN=UNCONNECTED3 VSS=DVSS VDD=DVDD
Xp95969A__2883 OAI211D0 $PINS A1=FE_RN_4 A2=n_63 B=FE_PHN45_n_67 C=sram_c_re
+ ZN=n_68 VSS=DVSS VDD=DVDD
Xcnt_c_reg[2] DFNCND1 $PINS CDN=FE_PHN43_BUS_RST_N CPN=CTS_1 D=FE_PHN44_n_64
+ Q=FE_OFN27_debug_cnt_c_2 QN=n_6 VSS=DVSS VDD=DVDD
Xp95679A__1666 NR2D0 $PINS A1=FE_PHN45_n_67 A2=n_3 ZN=n_70 VSS=DVSS VDD=DVDD
Xp96017A__7410 AOI21D0 $PINS A1=n_61 A2=n_52 B=FE_PHN35_CHC_START ZN=n_65
+ VSS=DVSS VDD=DVDD
Xcnt_c_reg[0] DFNCND1 $PINS CDN=FE_PHN43_BUS_RST_N CPN=CTS_1 D=n_57
+ Q=FE_OFN32_debug_cnt_c_0 QN=UNCONNECTED4 VSS=DVSS VDD=DVDD
Xp96050A__6417 NR2D1 $PINS A1=n_110 A2=FE_PHN35_CHC_START ZN=n_64 VSS=DVSS
+ VDD=DVDD
Xcnt_c_reg[1] DFNCND1 $PINS CDN=FE_PHN43_BUS_RST_N CPN=CTS_1 D=FE_PHN72_n_58
+ Q=FE_OFN30_debug_cnt_c_1 QN=UNCONNECTED5 VSS=DVSS VDD=DVDD
Xp95668A__5477 CKND2D0 $PINS A1=n_63 A2=FE_RN_4 ZN=n_67 VSS=DVSS VDD=DVDD
Xp95971A__2398 AOI21D0 $PINS A1=n_60 A2=FE_PHN37_n_0 B=n_63 ZN=n_62 VSS=DVSS
+ VDD=DVDD
Xp96026A__5107 OAI211D0 $PINS A1=sram_c_addr<3> A2=n_48 B=n_60 C=sram_c_re
+ ZN=n_61 VSS=DVSS VDD=DVDD
Xp96073A__4319 AOI21D0 $PINS A1=n_51 A2=n_53 B=FE_PHN35_CHC_START ZN=n_58
+ VSS=DVSS VDD=DVDD
Xp96118A__8428 NR2D0 $PINS A1=n_111 A2=FE_PHN35_CHC_START ZN=n_57 VSS=DVSS
+ VDD=DVDD
Xp95642A__5526 NR2D0 $PINS A1=n_60 A2=FE_PHN37_n_0 ZN=n_63 VSS=DVSS VDD=DVDD
Xp96142A317__3680 CKND2D0 $PINS A1=FE_OFN6_debug_cnt_c_9 A2=FE_PHN38_n_35
+ ZN=n_55 VSS=DVSS VDD=DVDD
Xp96142A316__1617 CKND2D0 $PINS A1=FE_PHN62_FE_OFN12_debug_cnt_c_7
+ A2=FE_PHN38_n_35 ZN=n_54 VSS=DVSS VDD=DVDD
Xp96142A315__2802 CKND2D0 $PINS A1=FE_RN_8 A2=FE_PHN38_n_35 ZN=n_53 VSS=DVSS
+ VDD=DVDD
Xp96142A318__1705 CKND2D0 $PINS A1=sram_c_addr<3> A2=FE_PHN38_n_35 ZN=n_52
+ VSS=DVSS VDD=DVDD
Xp96082A__5122 OAI211D0 $PINS A1=FE_PHN39_FE_OFN30_debug_cnt_c_1
+ A2=sram_c_addr<0> B=n_49 C=sram_c_re ZN=n_51 VSS=DVSS VDD=DVDD
Xp96028A__8246 AOI21D0 $PINS A1=n_49 A2=FE_PHN36_n_6 B=n_48 ZN=n_50 VSS=DVSS
+ VDD=DVDD
Xp96142A__7098 CKND2D0 $PINS A1=FE_RN_4 A2=FE_PHN38_n_35 ZN=n_47 VSS=DVSS
+ VDD=DVDD
Xp95632A__6131 CKND2D0 $PINS A1=n_48 A2=sram_c_addr<3> ZN=n_60 VSS=DVSS
+ VDD=DVDD
Xp95604A__1881 NR2D1 $PINS A1=n_49 A2=FE_PHN36_n_6 ZN=n_48 VSS=DVSS VDD=DVDD
Xp23609A INVD12 $PINS I=FE_PHN38_n_35 ZN=sram_c_re VSS=DVSS VDD=DVDD
Xp95591A__5115 CKND2D0 $PINS A1=sram_c_addr<0> A2=FE_RN_8 ZN=n_49 VSS=DVSS
+ VDD=DVDD
Xchc_rd_s_reg DFNCND1 $PINS CDN=FE_PHN43_BUS_RST_N CPN=CTS_1 D=FE_PHN42_CHC_RD
+ Q=UNCONNECTED6 QN=n_35 VSS=DVSS VDD=DVDD
Xg2 MUX2ND0 $PINS I0=FE_RN_1 I1=n_86 S=sram_c_re ZN=n_106 VSS=DVSS VDD=DVDD
Xg367 MUX2ND0 $PINS I0=FE_OFN9_debug_cnt_c_8 I1=n_77 S=sram_c_re ZN=n_107
+ VSS=DVSS VDD=DVDD
Xg368 MUX2ND0 $PINS I0=debug_cnt_c<6> I1=n_69 S=sram_c_re ZN=n_108 VSS=DVSS
+ VDD=DVDD
Xg369 MUX2ND0 $PINS I0=sram_c_addr<4> I1=n_62 S=sram_c_re ZN=n_109 VSS=DVSS
+ VDD=DVDD
Xg370 MUX2ND0 $PINS I0=sram_c_addr<2> I1=n_50 S=sram_c_re ZN=n_110 VSS=DVSS
+ VDD=DVDD
Xg371 XNR2D0 $PINS A1=sram_c_addr<0> A2=sram_c_re ZN=n_111 VSS=DVSS VDD=DVDD
XFILLER_T_7_150 DCAP4 $PINS VSS=DVSS VDD=DVDD
XFILLER_T_7_149 DCAP16 $PINS VSS=DVSS VDD=DVDD
XFILLER_T_6_153 DCAP4 $PINS VSS=DVSS VDD=DVDD
XFILLER_T_7_148 DCAP32 $PINS VSS=DVSS VDD=DVDD
XFILLER_T_6_152 DCAP16 $PINS VSS=DVSS VDD=DVDD
XFILLER_T_7_147 DCAP4 $PINS VSS=DVSS VDD=DVDD
XFILLER_T_6_151 DCAP32 $PINS VSS=DVSS VDD=DVDD
XFILLER_T_7_146 DCAP16 $PINS VSS=DVSS VDD=DVDD
XFILLER_T_6_150 DCAP4 $PINS VSS=DVSS VDD=DVDD
XFILLER_T_7_145 DCAP32 $PINS VSS=DVSS VDD=DVDD
XFILLER_T_6_149 DCAP16 $PINS VSS=DVSS VDD=DVDD
XFILLER_T_7_144 DCAP4 $PINS VSS=DVSS VDD=DVDD
XFILLER_T_6_148 DCAP32 $PINS VSS=DVSS VDD=DVDD
XFILLER_T_7_143 DCAP16 $PINS VSS=DVSS VDD=DVDD
XFILLER_T_6_147 DCAP4 $PINS VSS=DVSS VDD=DVDD
XFILLER_T_7_142 DCAP32 $PINS VSS=DVSS VDD=DVDD
XFILLER_T_8_150 DCAP4 $PINS VSS=DVSS VDD=DVDD
XFILLER_T_7_141 DCAP4 $PINS VSS=DVSS VDD=DVDD
XFILLER_T_8_149 DCAP16 $PINS VSS=DVSS VDD=DVDD
XFILLER_T_7_140 DCAP16 $PINS VSS=DVSS VDD=DVDD
XFILLER_T_8_148 DCAP32 $PINS VSS=DVSS VDD=DVDD
XFILLER_T_7_139 DCAP32 $PINS VSS=DVSS VDD=DVDD
XFILLER_T_8_147 DCAP4 $PINS VSS=DVSS VDD=DVDD
XFILLER_T_7_138 DCAP4 $PINS VSS=DVSS VDD=DVDD
XFILLER_T_8_146 DCAP16 $PINS VSS=DVSS VDD=DVDD
XFILLER_T_7_137 DCAP16 $PINS VSS=DVSS VDD=DVDD
XFILLER_T_8_145 DCAP32 $PINS VSS=DVSS VDD=DVDD
XFILLER_T_7_136 DCAP32 $PINS VSS=DVSS VDD=DVDD
XFILLER_T_8_144 DCAP4 $PINS VSS=DVSS VDD=DVDD
XFILLER_T_7_135 DCAP4 $PINS VSS=DVSS VDD=DVDD
XFILLER_T_8_143 DCAP16 $PINS VSS=DVSS VDD=DVDD
XFILLER_T_7_134 DCAP16 $PINS VSS=DVSS VDD=DVDD
XFILLER_T_8_142 DCAP32 $PINS VSS=DVSS VDD=DVDD
XFILLER_T_7_133 DCAP32 $PINS VSS=DVSS VDD=DVDD
XFILLER_T_8_141 DCAP4 $PINS VSS=DVSS VDD=DVDD
XFILLER_T_7_132 DCAP4 $PINS VSS=DVSS VDD=DVDD
XFILLER_T_6_146 DCAP16 $PINS VSS=DVSS VDD=DVDD
XFILLER_T_8_140 DCAP16 $PINS VSS=DVSS VDD=DVDD
XFILLER_T_7_131 DCAP16 $PINS VSS=DVSS VDD=DVDD
XFILLER_T_6_145 DCAP32 $PINS VSS=DVSS VDD=DVDD
XFILLER_T_8_139 DCAP32 $PINS VSS=DVSS VDD=DVDD
XFILLER_T_6_144 DCAP4 $PINS VSS=DVSS VDD=DVDD
XFILLER_T_8_138 DCAP4 $PINS VSS=DVSS VDD=DVDD
XFILLER_T_7_130 DCAP32 $PINS VSS=DVSS VDD=DVDD
XFILLER_T_6_143 DCAP16 $PINS VSS=DVSS VDD=DVDD
XFILLER_T_7_129 DCAP4 $PINS VSS=DVSS VDD=DVDD
XFILLER_T_6_142 DCAP32 $PINS VSS=DVSS VDD=DVDD
XFILLER_T_7_128 DCAP16 $PINS VSS=DVSS VDD=DVDD
XFILLER_T_6_141 DCAP4 $PINS VSS=DVSS VDD=DVDD
XFILLER_T_7_127 DCAP32 $PINS VSS=DVSS VDD=DVDD
XFILLER_T_6_140 DCAP16 $PINS VSS=DVSS VDD=DVDD
XFILLER_T_7_126 DCAP4 $PINS VSS=DVSS VDD=DVDD
XFILLER_T_8_137 DCAP16 $PINS VSS=DVSS VDD=DVDD
XFILLER_T_6_139 DCAP32 $PINS VSS=DVSS VDD=DVDD
XFILLER_T_7_125 DCAP16 $PINS VSS=DVSS VDD=DVDD
XFILLER_T_8_136 DCAP32 $PINS VSS=DVSS VDD=DVDD
XFILLER_T_6_138 DCAP4 $PINS VSS=DVSS VDD=DVDD
XFILLER_T_8_135 DCAP4 $PINS VSS=DVSS VDD=DVDD
XFILLER_T_7_124 DCAP32 $PINS VSS=DVSS VDD=DVDD
XFILLER_T_6_137 DCAP16 $PINS VSS=DVSS VDD=DVDD
XFILLER_T_8_134 DCAP16 $PINS VSS=DVSS VDD=DVDD
XFILLER_T_7_123 DCAP4 $PINS VSS=DVSS VDD=DVDD
XFILLER_T_6_136 DCAP32 $PINS VSS=DVSS VDD=DVDD
XFILLER_T_8_133 DCAP32 $PINS VSS=DVSS VDD=DVDD
XFILLER_T_7_122 DCAP16 $PINS VSS=DVSS VDD=DVDD
XFILLER_T_8_132 DCAP4 $PINS VSS=DVSS VDD=DVDD
XFILLER_T_7_121 DCAP32 $PINS VSS=DVSS VDD=DVDD
XFILLER_T_8_131 DCAP16 $PINS VSS=DVSS VDD=DVDD
XFILLER_T_7_120 DCAP4 $PINS VSS=DVSS VDD=DVDD
XFILLER_T_6_135 DCAP4 $PINS VSS=DVSS VDD=DVDD
XFILLER_T_8_130 DCAP32 $PINS VSS=DVSS VDD=DVDD
XFILLER_T_7_119 DCAP16 $PINS VSS=DVSS VDD=DVDD
XFILLER_T_6_134 DCAP16 $PINS VSS=DVSS VDD=DVDD
XFILLER_T_8_129 DCAP4 $PINS VSS=DVSS VDD=DVDD
XFILLER_T_7_118 DCAP32 $PINS VSS=DVSS VDD=DVDD
XFILLER_T_6_133 DCAP32 $PINS VSS=DVSS VDD=DVDD
XFILLER_T_8_128 DCAP16 $PINS VSS=DVSS VDD=DVDD
XFILLER_T_7_117 DCAP4 $PINS VSS=DVSS VDD=DVDD
XFILLER_T_6_132 DCAP4 $PINS VSS=DVSS VDD=DVDD
XFILLER_T_8_127 DCAP32 $PINS VSS=DVSS VDD=DVDD
XFILLER_T_7_116 DCAP16 $PINS VSS=DVSS VDD=DVDD
XFILLER_T_8_126 DCAP4 $PINS VSS=DVSS VDD=DVDD
XFILLER_T_7_115 DCAP32 $PINS VSS=DVSS VDD=DVDD
XFILLER_T_8_125 DCAP16 $PINS VSS=DVSS VDD=DVDD
XFILLER_T_7_114 DCAP4 $PINS VSS=DVSS VDD=DVDD
XFILLER_T_8_124 DCAP32 $PINS VSS=DVSS VDD=DVDD
XFILLER_T_7_113 DCAP16 $PINS VSS=DVSS VDD=DVDD
XFILLER_T_8_123 DCAP4 $PINS VSS=DVSS VDD=DVDD
XFILLER_T_7_112 DCAP32 $PINS VSS=DVSS VDD=DVDD
XFILLER_T_8_122 DCAP16 $PINS VSS=DVSS VDD=DVDD
XFILLER_T_7_111 DCAP4 $PINS VSS=DVSS VDD=DVDD
XFILLER_T_8_121 DCAP32 $PINS VSS=DVSS VDD=DVDD
XFILLER_T_7_110 DCAP16 $PINS VSS=DVSS VDD=DVDD
XFILLER_T_8_120 DCAP4 $PINS VSS=DVSS VDD=DVDD
XFILLER_T_6_131 DCAP16 $PINS VSS=DVSS VDD=DVDD
XFILLER_T_7_109 DCAP32 $PINS VSS=DVSS VDD=DVDD
XFILLER_T_8_119 DCAP16 $PINS VSS=DVSS VDD=DVDD
XFILLER_T_7_108 DCAP4 $PINS VSS=DVSS VDD=DVDD
XFILLER_T_6_130 DCAP32 $PINS VSS=DVSS VDD=DVDD
XFILLER_T_7_107 DCAP16 $PINS VSS=DVSS VDD=DVDD
XFILLER_T_6_129 DCAP4 $PINS VSS=DVSS VDD=DVDD
XFILLER_T_8_118 DCAP32 $PINS VSS=DVSS VDD=DVDD
XFILLER_T_7_106 DCAP32 $PINS VSS=DVSS VDD=DVDD
XFILLER_T_8_117 DCAP4 $PINS VSS=DVSS VDD=DVDD
XFILLER_T_7_105 DCAP4 $PINS VSS=DVSS VDD=DVDD
XFILLER_T_6_128 DCAP16 $PINS VSS=DVSS VDD=DVDD
XFILLER_T_8_116 DCAP16 $PINS VSS=DVSS VDD=DVDD
XFILLER_T_7_104 DCAP16 $PINS VSS=DVSS VDD=DVDD
XFILLER_T_6_127 DCAP32 $PINS VSS=DVSS VDD=DVDD
XFILLER_T_8_115 DCAP32 $PINS VSS=DVSS VDD=DVDD
XFILLER_T_7_103 DCAP32 $PINS VSS=DVSS VDD=DVDD
XFILLER_T_6_126 DCAP4 $PINS VSS=DVSS VDD=DVDD
XFILLER_T_7_102 DCAP4 $PINS VSS=DVSS VDD=DVDD
XFILLER_T_8_114 DCAP4 $PINS VSS=DVSS VDD=DVDD
XFILLER_T_7_101 DCAP16 $PINS VSS=DVSS VDD=DVDD
XFILLER_T_6_125 DCAP16 $PINS VSS=DVSS VDD=DVDD
XFILLER_T_8_113 DCAP16 $PINS VSS=DVSS VDD=DVDD
XFILLER_T_7_100 DCAP32 $PINS VSS=DVSS VDD=DVDD
XFILLER_T_6_124 DCAP32 $PINS VSS=DVSS VDD=DVDD
XFILLER_T_7_99 DCAP4 $PINS VSS=DVSS VDD=DVDD
XFILLER_T_8_112 DCAP32 $PINS VSS=DVSS VDD=DVDD
XFILLER_T_6_123 DCAP4 $PINS VSS=DVSS VDD=DVDD
XFILLER_T_8_111 DCAP4 $PINS VSS=DVSS VDD=DVDD
XFILLER_T_7_98 DCAP16 $PINS VSS=DVSS VDD=DVDD
XFILLER_T_6_122 DCAP16 $PINS VSS=DVSS VDD=DVDD
XFILLER_T_7_97 DCAP32 $PINS VSS=DVSS VDD=DVDD
XFILLER_T_8_110 DCAP16 $PINS VSS=DVSS VDD=DVDD
XFILLER_T_6_121 DCAP32 $PINS VSS=DVSS VDD=DVDD
XFILLER_T_8_109 DCAP32 $PINS VSS=DVSS VDD=DVDD
XFILLER_T_7_96 DCAP4 $PINS VSS=DVSS VDD=DVDD
XFILLER_T_6_120 DCAP4 $PINS VSS=DVSS VDD=DVDD
XFILLER_T_8_108 DCAP4 $PINS VSS=DVSS VDD=DVDD
XFILLER_T_6_119 DCAP16 $PINS VSS=DVSS VDD=DVDD
XFILLER_T_7_95 DCAP16 $PINS VSS=DVSS VDD=DVDD
XFILLER_T_7_94 DCAP32 $PINS VSS=DVSS VDD=DVDD
XFILLER_T_8_107 DCAP16 $PINS VSS=DVSS VDD=DVDD
XFILLER_T_7_93 DCAP4 $PINS VSS=DVSS VDD=DVDD
XFILLER_T_6_118 DCAP32 $PINS VSS=DVSS VDD=DVDD
XFILLER_T_8_106 DCAP32 $PINS VSS=DVSS VDD=DVDD
XFILLER_T_7_92 DCAP16 $PINS VSS=DVSS VDD=DVDD
XFILLER_T_8_105 DCAP4 $PINS VSS=DVSS VDD=DVDD
XFILLER_T_7_91 DCAP32 $PINS VSS=DVSS VDD=DVDD
XFILLER_T_8_104 DCAP16 $PINS VSS=DVSS VDD=DVDD
XFILLER_T_7_90 DCAP4 $PINS VSS=DVSS VDD=DVDD
XFILLER_T_6_117 DCAP4 $PINS VSS=DVSS VDD=DVDD
XFILLER_T_8_103 DCAP32 $PINS VSS=DVSS VDD=DVDD
XFILLER_T_7_89 DCAP16 $PINS VSS=DVSS VDD=DVDD
XFILLER_T_8_102 DCAP4 $PINS VSS=DVSS VDD=DVDD
XFILLER_T_7_88 DCAP32 $PINS VSS=DVSS VDD=DVDD
XFILLER_T_8_101 DCAP16 $PINS VSS=DVSS VDD=DVDD
XFILLER_T_7_87 DCAP4 $PINS VSS=DVSS VDD=DVDD
XFILLER_T_6_116 DCAP16 $PINS VSS=DVSS VDD=DVDD
XFILLER_T_8_100 DCAP32 $PINS VSS=DVSS VDD=DVDD
XFILLER_T_7_86 DCAP16 $PINS VSS=DVSS VDD=DVDD
XFILLER_T_6_115 DCAP32 $PINS VSS=DVSS VDD=DVDD
XFILLER_T_8_99 DCAP4 $PINS VSS=DVSS VDD=DVDD
XFILLER_T_6_114 DCAP4 $PINS VSS=DVSS VDD=DVDD
XFILLER_T_8_98 DCAP16 $PINS VSS=DVSS VDD=DVDD
XFILLER_T_6_113 DCAP16 $PINS VSS=DVSS VDD=DVDD
XFILLER_T_7_85 DCAP32 $PINS VSS=DVSS VDD=DVDD
XFILLER_T_8_97 DCAP32 $PINS VSS=DVSS VDD=DVDD
XFILLER_T_6_112 DCAP32 $PINS VSS=DVSS VDD=DVDD
XFILLER_T_8_96 DCAP4 $PINS VSS=DVSS VDD=DVDD
XFILLER_T_7_84 DCAP4 $PINS VSS=DVSS VDD=DVDD
XFILLER_T_6_111 DCAP4 $PINS VSS=DVSS VDD=DVDD
XFILLER_T_7_83 DCAP16 $PINS VSS=DVSS VDD=DVDD
XFILLER_T_6_110 DCAP16 $PINS VSS=DVSS VDD=DVDD
XFILLER_T_8_95 DCAP16 $PINS VSS=DVSS VDD=DVDD
XFILLER_T_7_82 DCAP32 $PINS VSS=DVSS VDD=DVDD
XFILLER_T_6_109 DCAP32 $PINS VSS=DVSS VDD=DVDD
XFILLER_T_7_81 DCAP4 $PINS VSS=DVSS VDD=DVDD
XFILLER_T_8_94 DCAP32 $PINS VSS=DVSS VDD=DVDD
XFILLER_T_6_108 DCAP4 $PINS VSS=DVSS VDD=DVDD
XFILLER_T_8_93 DCAP4 $PINS VSS=DVSS VDD=DVDD
XFILLER_T_7_80 DCAP16 $PINS VSS=DVSS VDD=DVDD
XFILLER_T_6_107 DCAP16 $PINS VSS=DVSS VDD=DVDD
XFILLER_T_7_79 DCAP32 $PINS VSS=DVSS VDD=DVDD
XFILLER_T_8_92 DCAP16 $PINS VSS=DVSS VDD=DVDD
XFILLER_T_6_106 DCAP32 $PINS VSS=DVSS VDD=DVDD
XFILLER_T_8_91 DCAP32 $PINS VSS=DVSS VDD=DVDD
XFILLER_T_6_105 DCAP4 $PINS VSS=DVSS VDD=DVDD
XFILLER_T_8_90 DCAP4 $PINS VSS=DVSS VDD=DVDD
XFILLER_T_6_104 DCAP16 $PINS VSS=DVSS VDD=DVDD
XFILLER_T_8_89 DCAP16 $PINS VSS=DVSS VDD=DVDD
XFILLER_T_6_103 DCAP32 $PINS VSS=DVSS VDD=DVDD
XFILLER_T_8_88 DCAP32 $PINS VSS=DVSS VDD=DVDD
XFILLER_T_6_102 DCAP4 $PINS VSS=DVSS VDD=DVDD
XFILLER_T_7_78 DCAP4 $PINS VSS=DVSS VDD=DVDD
XFILLER_T_6_101 DCAP16 $PINS VSS=DVSS VDD=DVDD
XFILLER_T_7_77 DCAP16 $PINS VSS=DVSS VDD=DVDD
XFILLER_T_6_100 DCAP32 $PINS VSS=DVSS VDD=DVDD
XFILLER_T_7_76 DCAP32 $PINS VSS=DVSS VDD=DVDD
XFILLER_T_6_99 DCAP4 $PINS VSS=DVSS VDD=DVDD
XFILLER_T_8_87 DCAP4 $PINS VSS=DVSS VDD=DVDD
XFILLER_T_6_98 DCAP16 $PINS VSS=DVSS VDD=DVDD
XFILLER_T_7_75 DCAP4 $PINS VSS=DVSS VDD=DVDD
XFILLER_T_8_86 DCAP16 $PINS VSS=DVSS VDD=DVDD
XFILLER_T_6_97 DCAP32 $PINS VSS=DVSS VDD=DVDD
XFILLER_T_8_85 DCAP32 $PINS VSS=DVSS VDD=DVDD
XFILLER_T_6_96 DCAP4 $PINS VSS=DVSS VDD=DVDD
XFILLER_T_8_84 DCAP4 $PINS VSS=DVSS VDD=DVDD
XFILLER_T_6_95 DCAP16 $PINS VSS=DVSS VDD=DVDD
XFILLER_T_8_83 DCAP16 $PINS VSS=DVSS VDD=DVDD
XFILLER_T_6_94 DCAP32 $PINS VSS=DVSS VDD=DVDD
XFILLER_T_8_82 DCAP32 $PINS VSS=DVSS VDD=DVDD
XFILLER_T_6_93 DCAP4 $PINS VSS=DVSS VDD=DVDD
XFILLER_T_7_74 DCAP16 $PINS VSS=DVSS VDD=DVDD
XFILLER_T_6_92 DCAP16 $PINS VSS=DVSS VDD=DVDD
XFILLER_T_7_73 DCAP32 $PINS VSS=DVSS VDD=DVDD
XFILLER_T_6_91 DCAP32 $PINS VSS=DVSS VDD=DVDD
XFILLER_T_7_72 DCAP4 $PINS VSS=DVSS VDD=DVDD
XFILLER_T_6_90 DCAP4 $PINS VSS=DVSS VDD=DVDD
XFILLER_T_8_81 DCAP4 $PINS VSS=DVSS VDD=DVDD
XFILLER_T_6_89 DCAP16 $PINS VSS=DVSS VDD=DVDD
XFILLER_T_7_71 DCAP16 $PINS VSS=DVSS VDD=DVDD
XFILLER_T_8_80 DCAP16 $PINS VSS=DVSS VDD=DVDD
XFILLER_T_6_88 DCAP32 $PINS VSS=DVSS VDD=DVDD
XFILLER_T_7_70 DCAP32 $PINS VSS=DVSS VDD=DVDD
XFILLER_T_8_79 DCAP32 $PINS VSS=DVSS VDD=DVDD
XFILLER_T_6_87 DCAP4 $PINS VSS=DVSS VDD=DVDD
XFILLER_T_8_78 DCAP4 $PINS VSS=DVSS VDD=DVDD
XFILLER_T_6_86 DCAP16 $PINS VSS=DVSS VDD=DVDD
XFILLER_T_8_77 DCAP16 $PINS VSS=DVSS VDD=DVDD
XFILLER_T_6_85 DCAP32 $PINS VSS=DVSS VDD=DVDD
XFILLER_T_8_76 DCAP32 $PINS VSS=DVSS VDD=DVDD
XFILLER_T_6_84 DCAP4 $PINS VSS=DVSS VDD=DVDD
XFILLER_T_7_69 DCAP4 $PINS VSS=DVSS VDD=DVDD
XFILLER_T_6_83 DCAP16 $PINS VSS=DVSS VDD=DVDD
XFILLER_T_8_75 DCAP4 $PINS VSS=DVSS VDD=DVDD
XFILLER_T_7_68 DCAP16 $PINS VSS=DVSS VDD=DVDD
XFILLER_T_6_82 DCAP32 $PINS VSS=DVSS VDD=DVDD
XFILLER_T_8_74 DCAP16 $PINS VSS=DVSS VDD=DVDD
XFILLER_T_7_67 DCAP32 $PINS VSS=DVSS VDD=DVDD
XFILLER_T_6_81 DCAP4 $PINS VSS=DVSS VDD=DVDD
XFILLER_T_7_66 DCAP4 $PINS VSS=DVSS VDD=DVDD
XFILLER_T_8_73 DCAP32 $PINS VSS=DVSS VDD=DVDD
XFILLER_T_6_80 DCAP16 $PINS VSS=DVSS VDD=DVDD
XFILLER_T_8_72 DCAP4 $PINS VSS=DVSS VDD=DVDD
XFILLER_T_7_65 DCAP16 $PINS VSS=DVSS VDD=DVDD
XFILLER_T_6_79 DCAP32 $PINS VSS=DVSS VDD=DVDD
XFILLER_T_8_71 DCAP16 $PINS VSS=DVSS VDD=DVDD
XFILLER_T_7_64 DCAP32 $PINS VSS=DVSS VDD=DVDD
XFILLER_T_6_78 DCAP4 $PINS VSS=DVSS VDD=DVDD
XFILLER_T_7_63 DCAP4 $PINS VSS=DVSS VDD=DVDD
XFILLER_T_8_70 DCAP32 $PINS VSS=DVSS VDD=DVDD
XFILLER_T_6_77 DCAP16 $PINS VSS=DVSS VDD=DVDD
XFILLER_T_8_69 DCAP4 $PINS VSS=DVSS VDD=DVDD
XFILLER_T_7_62 DCAP16 $PINS VSS=DVSS VDD=DVDD
XFILLER_T_6_76 DCAP32 $PINS VSS=DVSS VDD=DVDD
XFILLER_T_8_68 DCAP16 $PINS VSS=DVSS VDD=DVDD
XFILLER_T_7_61 DCAP32 $PINS VSS=DVSS VDD=DVDD
XFILLER_T_6_75 DCAP4 $PINS VSS=DVSS VDD=DVDD
XFILLER_T_8_67 DCAP32 $PINS VSS=DVSS VDD=DVDD
XFILLER_T_7_60 DCAP4 $PINS VSS=DVSS VDD=DVDD
XFILLER_T_6_74 DCAP16 $PINS VSS=DVSS VDD=DVDD
XFILLER_T_8_66 DCAP4 $PINS VSS=DVSS VDD=DVDD
XFILLER_T_6_73 DCAP32 $PINS VSS=DVSS VDD=DVDD
XFILLER_T_8_65 DCAP16 $PINS VSS=DVSS VDD=DVDD
XFILLER_T_6_72 DCAP4 $PINS VSS=DVSS VDD=DVDD
XFILLER_T_7_59 DCAP16 $PINS VSS=DVSS VDD=DVDD
XFILLER_T_6_71 DCAP16 $PINS VSS=DVSS VDD=DVDD
XFILLER_T_7_58 DCAP32 $PINS VSS=DVSS VDD=DVDD
XFILLER_T_6_70 DCAP32 $PINS VSS=DVSS VDD=DVDD
XFILLER_T_8_64 DCAP32 $PINS VSS=DVSS VDD=DVDD
XFILLER_T_7_57 DCAP4 $PINS VSS=DVSS VDD=DVDD
XFILLER_T_6_69 DCAP4 $PINS VSS=DVSS VDD=DVDD
XFILLER_T_7_56 DCAP16 $PINS VSS=DVSS VDD=DVDD
XFILLER_T_6_68 DCAP16 $PINS VSS=DVSS VDD=DVDD
XFILLER_T_7_55 DCAP32 $PINS VSS=DVSS VDD=DVDD
XFILLER_T_8_63 DCAP4 $PINS VSS=DVSS VDD=DVDD
XFILLER_T_6_67 DCAP32 $PINS VSS=DVSS VDD=DVDD
XFILLER_T_8_62 DCAP16 $PINS VSS=DVSS VDD=DVDD
XFILLER_T_6_66 DCAP4 $PINS VSS=DVSS VDD=DVDD
XFILLER_T_7_54 DCAP4 $PINS VSS=DVSS VDD=DVDD
XFILLER_T_8_61 DCAP32 $PINS VSS=DVSS VDD=DVDD
XFILLER_T_6_65 DCAP8 $PINS VSS=DVSS VDD=DVDD
XFILLER_T_8_60 DCAP4 $PINS VSS=DVSS VDD=DVDD
XFILLER_T_7_53 DCAP16 $PINS VSS=DVSS VDD=DVDD
XFILLER_T_6_64 DCAP16 $PINS VSS=DVSS VDD=DVDD
XFILLER_T_7_52 DCAP32 $PINS VSS=DVSS VDD=DVDD
XFILLER_T_8_59 DCAP16 $PINS VSS=DVSS VDD=DVDD
XFILLER_T_7_51 DCAP4 $PINS VSS=DVSS VDD=DVDD
XFILLER_T_8_58 DCAP32 $PINS VSS=DVSS VDD=DVDD
XFILLER_T_7_50 DCAP16 $PINS VSS=DVSS VDD=DVDD
XFILLER_T_8_57 DCAP4 $PINS VSS=DVSS VDD=DVDD
XFILLER_T_7_49 DCAP32 $PINS VSS=DVSS VDD=DVDD
XFILLER_T_6_61 DCAP8 $PINS VSS=DVSS VDD=DVDD
XFILLER_T_8_56 DCAP16 $PINS VSS=DVSS VDD=DVDD
XFILLER_T_7_48 DCAP4 $PINS VSS=DVSS VDD=DVDD
XFILLER_T_6_60 DCAP4 $PINS VSS=DVSS VDD=DVDD
XFILLER_T_7_47 DCAP16 $PINS VSS=DVSS VDD=DVDD
XFILLER_T_6_59 DCAP16 $PINS VSS=DVSS VDD=DVDD
XFILLER_T_8_55 DCAP32 $PINS VSS=DVSS VDD=DVDD
XFILLER_T_6_58 DCAP32 $PINS VSS=DVSS VDD=DVDD
XFILLER_T_8_54 DCAP4 $PINS VSS=DVSS VDD=DVDD
XFILLER_T_6_57 DCAP4 $PINS VSS=DVSS VDD=DVDD
XFILLER_T_7_46 DCAP32 $PINS VSS=DVSS VDD=DVDD
XFILLER_T_8_53 DCAP16 $PINS VSS=DVSS VDD=DVDD
XFILLER_T_7_45 DCAP4 $PINS VSS=DVSS VDD=DVDD
XFILLER_T_8_52 DCAP32 $PINS VSS=DVSS VDD=DVDD
XFILLER_T_7_44 DCAP16 $PINS VSS=DVSS VDD=DVDD
XFILLER_T_8_51 DCAP4 $PINS VSS=DVSS VDD=DVDD
XFILLER_T_6_56 DCAP16 $PINS VSS=DVSS VDD=DVDD
XFILLER_T_8_50 DCAP16 $PINS VSS=DVSS VDD=DVDD
XFILLER_T_6_55 DCAP32 $PINS VSS=DVSS VDD=DVDD
XFILLER_T_8_49 DCAP32 $PINS VSS=DVSS VDD=DVDD
XFILLER_T_6_54 DCAP4 $PINS VSS=DVSS VDD=DVDD
XFILLER_T_7_43 DCAP32 $PINS VSS=DVSS VDD=DVDD
XFILLER_T_8_48 DCAP4 $PINS VSS=DVSS VDD=DVDD
XFILLER_T_7_42 DCAP4 $PINS VSS=DVSS VDD=DVDD
XFILLER_T_8_47 DCAP16 $PINS VSS=DVSS VDD=DVDD
XFILLER_T_7_41 DCAP16 $PINS VSS=DVSS VDD=DVDD
XFILLER_T_8_46 DCAP32 $PINS VSS=DVSS VDD=DVDD
XFILLER_T_6_53 DCAP16 $PINS VSS=DVSS VDD=DVDD
XFILLER_T_7_40 DCAP32 $PINS VSS=DVSS VDD=DVDD
XFILLER_T_6_52 DCAP32 $PINS VSS=DVSS VDD=DVDD
XFILLER_T_8_45 DCAP4 $PINS VSS=DVSS VDD=DVDD
XFILLER_T_7_39 DCAP4 $PINS VSS=DVSS VDD=DVDD
XFILLER_T_6_51 DCAP4 $PINS VSS=DVSS VDD=DVDD
XFILLER_T_7_38 DCAP16 $PINS VSS=DVSS VDD=DVDD
XFILLER_T_6_50 DCAP16 $PINS VSS=DVSS VDD=DVDD
XFILLER_T_7_37 DCAP32 $PINS VSS=DVSS VDD=DVDD
XFILLER_T_6_49 DCAP32 $PINS VSS=DVSS VDD=DVDD
XFILLER_T_7_36 DCAP4 $PINS VSS=DVSS VDD=DVDD
XFILLER_T_6_48 DCAP4 $PINS VSS=DVSS VDD=DVDD
XFILLER_T_8_44 DCAP16 $PINS VSS=DVSS VDD=DVDD
XFILLER_T_6_47 DCAP16 $PINS VSS=DVSS VDD=DVDD
XFILLER_T_8_43 DCAP32 $PINS VSS=DVSS VDD=DVDD
XFILLER_T_6_46 DCAP32 $PINS VSS=DVSS VDD=DVDD
XFILLER_T_7_35 DCAP16 $PINS VSS=DVSS VDD=DVDD
XFILLER_T_8_42 DCAP4 $PINS VSS=DVSS VDD=DVDD
XFILLER_T_7_34 DCAP32 $PINS VSS=DVSS VDD=DVDD
XFILLER_T_8_41 DCAP16 $PINS VSS=DVSS VDD=DVDD
XFILLER_T_7_33 DCAP4 $PINS VSS=DVSS VDD=DVDD
XFILLER_T_8_40 DCAP32 $PINS VSS=DVSS VDD=DVDD
XFILLER_T_7_32 DCAP16 $PINS VSS=DVSS VDD=DVDD
XFILLER_T_8_39 DCAP4 $PINS VSS=DVSS VDD=DVDD
XFILLER_T_6_45 DCAP4 $PINS VSS=DVSS VDD=DVDD
XFILLER_T_8_38 DCAP16 $PINS VSS=DVSS VDD=DVDD
XFILLER_T_6_44 DCAP16 $PINS VSS=DVSS VDD=DVDD
XFILLER_T_7_31 DCAP32 $PINS VSS=DVSS VDD=DVDD
XFILLER_T_8_37 DCAP32 $PINS VSS=DVSS VDD=DVDD
XFILLER_T_6_43 DCAP32 $PINS VSS=DVSS VDD=DVDD
XFILLER_T_8_36 DCAP4 $PINS VSS=DVSS VDD=DVDD
XFILLER_T_7_30 DCAP4 $PINS VSS=DVSS VDD=DVDD
XFILLER_T_6_42 DCAP4 $PINS VSS=DVSS VDD=DVDD
XFILLER_T_8_35 DCAP16 $PINS VSS=DVSS VDD=DVDD
XFILLER_T_7_29 DCAP16 $PINS VSS=DVSS VDD=DVDD
XFILLER_T_6_41 DCAP16 $PINS VSS=DVSS VDD=DVDD
XFILLER_T_7_28 DCAP32 $PINS VSS=DVSS VDD=DVDD
XFILLER_T_6_40 DCAP32 $PINS VSS=DVSS VDD=DVDD
XFILLER_T_8_34 DCAP32 $PINS VSS=DVSS VDD=DVDD
XFILLER_T_7_27 DCAP4 $PINS VSS=DVSS VDD=DVDD
XFILLER_T_8_33 DCAP4 $PINS VSS=DVSS VDD=DVDD
XFILLER_T_6_39 DCAP4 $PINS VSS=DVSS VDD=DVDD
XFILLER_T_8_32 DCAP16 $PINS VSS=DVSS VDD=DVDD
XFILLER_T_6_38 DCAP16 $PINS VSS=DVSS VDD=DVDD
XFILLER_T_7_26 DCAP16 $PINS VSS=DVSS VDD=DVDD
XFILLER_T_8_31 DCAP32 $PINS VSS=DVSS VDD=DVDD
XFILLER_T_6_37 DCAP32 $PINS VSS=DVSS VDD=DVDD
XFILLER_T_8_30 DCAP4 $PINS VSS=DVSS VDD=DVDD
XFILLER_T_6_36 DCAP4 $PINS VSS=DVSS VDD=DVDD
XFILLER_T_8_29 DCAP16 $PINS VSS=DVSS VDD=DVDD
XFILLER_T_6_35 DCAP16 $PINS VSS=DVSS VDD=DVDD
XFILLER_T_8_28 DCAP32 $PINS VSS=DVSS VDD=DVDD
XFILLER_T_6_34 DCAP32 $PINS VSS=DVSS VDD=DVDD
XFILLER_T_7_25 DCAP32 $PINS VSS=DVSS VDD=DVDD
XFILLER_T_8_27 DCAP4 $PINS VSS=DVSS VDD=DVDD
XFILLER_T_6_33 DCAP4 $PINS VSS=DVSS VDD=DVDD
XFILLER_T_8_26 DCAP16 $PINS VSS=DVSS VDD=DVDD
XFILLER_T_6_32 DCAP16 $PINS VSS=DVSS VDD=DVDD
XFILLER_T_7_24 DCAP4 $PINS VSS=DVSS VDD=DVDD
XFILLER_T_8_25 DCAP32 $PINS VSS=DVSS VDD=DVDD
XFILLER_T_6_31 DCAP32 $PINS VSS=DVSS VDD=DVDD
XFILLER_T_8_24 DCAP4 $PINS VSS=DVSS VDD=DVDD
XFILLER_T_7_23 DCAP16 $PINS VSS=DVSS VDD=DVDD
XFILLER_T_6_30 DCAP4 $PINS VSS=DVSS VDD=DVDD
XFILLER_T_7_22 DCAP32 $PINS VSS=DVSS VDD=DVDD
XFILLER_T_6_29 DCAP16 $PINS VSS=DVSS VDD=DVDD
XFILLER_T_8_23 DCAP16 $PINS VSS=DVSS VDD=DVDD
XFILLER_T_7_21 DCAP4 $PINS VSS=DVSS VDD=DVDD
XFILLER_T_8_22 DCAP32 $PINS VSS=DVSS VDD=DVDD
XFILLER_T_7_20 DCAP16 $PINS VSS=DVSS VDD=DVDD
XFILLER_T_8_21 DCAP4 $PINS VSS=DVSS VDD=DVDD
XFILLER_T_6_28 DCAP32 $PINS VSS=DVSS VDD=DVDD
XFILLER_T_8_20 DCAP16 $PINS VSS=DVSS VDD=DVDD
XFILLER_T_6_27 DCAP4 $PINS VSS=DVSS VDD=DVDD
XFILLER_T_7_19 DCAP32 $PINS VSS=DVSS VDD=DVDD
XFILLER_T_8_19 DCAP32 $PINS VSS=DVSS VDD=DVDD
XFILLER_T_6_26 DCAP16 $PINS VSS=DVSS VDD=DVDD
XFILLER_T_8_18 DCAP4 $PINS VSS=DVSS VDD=DVDD
XFILLER_T_7_18 DCAP4 $PINS VSS=DVSS VDD=DVDD
XFILLER_T_6_25 DCAP32 $PINS VSS=DVSS VDD=DVDD
XFILLER_T_7_17 DCAP16 $PINS VSS=DVSS VDD=DVDD
XFILLER_T_6_24 DCAP4 $PINS VSS=DVSS VDD=DVDD
XFILLER_T_8_17 DCAP16 $PINS VSS=DVSS VDD=DVDD
XFILLER_T_6_23 DCAP16 $PINS VSS=DVSS VDD=DVDD
XFILLER_T_7_16 DCAP32 $PINS VSS=DVSS VDD=DVDD
XFILLER_T_7_15 DCAP4 $PINS VSS=DVSS VDD=DVDD
XFILLER_T_7_14 DCAP16 $PINS VSS=DVSS VDD=DVDD
XFILLER_T_9_9 DCAP32 $PINS VSS=DVSS VDD=DVDD
XFILLER_T_8_16 DCAP32 $PINS VSS=DVSS VDD=DVDD
XFILLER_T_6_22 DCAP32 $PINS VSS=DVSS VDD=DVDD
XFILLER_T_8_15 DCAP4 $PINS VSS=DVSS VDD=DVDD
XFILLER_T_7_13 DCAP32 $PINS VSS=DVSS VDD=DVDD
XFILLER_T_6_21 DCAP4 $PINS VSS=DVSS VDD=DVDD
XFILLER_T_7_12 DCAP4 $PINS VSS=DVSS VDD=DVDD
XFILLER_T_8_14 DCAP16 $PINS VSS=DVSS VDD=DVDD
XFILLER_T_6_20 DCAP16 $PINS VSS=DVSS VDD=DVDD
XFILLER_T_8_13 DCAP32 $PINS VSS=DVSS VDD=DVDD
XFILLER_T_6_19 DCAP32 $PINS VSS=DVSS VDD=DVDD
XFILLER_T_8_12 DCAP4 $PINS VSS=DVSS VDD=DVDD
XFILLER_T_6_18 DCAP4 $PINS VSS=DVSS VDD=DVDD
XFILLER_T_8_11 DCAP16 $PINS VSS=DVSS VDD=DVDD
XFILLER_T_6_17 DCAP16 $PINS VSS=DVSS VDD=DVDD
XFILLER_T_7_11 DCAP16 $PINS VSS=DVSS VDD=DVDD
XFILLER_T_6_16 DCAP32 $PINS VSS=DVSS VDD=DVDD
XFILLER_T_7_10 DCAP32 $PINS VSS=DVSS VDD=DVDD
XFILLER_T_6_15 DCAP4 $PINS VSS=DVSS VDD=DVDD
XFILLER_T_8_10 DCAP32 $PINS VSS=DVSS VDD=DVDD
XFILLER_T_6_14 DCAP16 $PINS VSS=DVSS VDD=DVDD
XFILLER_T_8_9 DCAP4 $PINS VSS=DVSS VDD=DVDD
XFILLER_T_6_13 DCAP32 $PINS VSS=DVSS VDD=DVDD
XFILLER_T_8_8 DCAP16 $PINS VSS=DVSS VDD=DVDD
XFILLER_T_6_12 DCAP4 $PINS VSS=DVSS VDD=DVDD
XFILLER_T_7_9 DCAP4 $PINS VSS=DVSS VDD=DVDD
XFILLER_T_6_11 DCAP16 $PINS VSS=DVSS VDD=DVDD
XFILLER_T_8_7 DCAP32 $PINS VSS=DVSS VDD=DVDD
XFILLER_T_9_6 DCAP4 $PINS VSS=DVSS VDD=DVDD
XFILLER_T_8_6 DCAP4 $PINS VSS=DVSS VDD=DVDD
XFILLER_T_6_10 DCAP32 $PINS VSS=DVSS VDD=DVDD
XFILLER_T_7_8 DCAP16 $PINS VSS=DVSS VDD=DVDD
XFILLER_T_9_5 DCAP16 $PINS VSS=DVSS VDD=DVDD
XFILLER_T_8_5 DCAP16 $PINS VSS=DVSS VDD=DVDD
XFILLER_T_6_9 DCAP4 $PINS VSS=DVSS VDD=DVDD
XFILLER_T_8_4 DCAP32 $PINS VSS=DVSS VDD=DVDD
XFILLER_T_9_4 DCAP32 $PINS VSS=DVSS VDD=DVDD
XFILLER_T_7_7 DCAP32 $PINS VSS=DVSS VDD=DVDD
XFILLER_T_6_8 DCAP16 $PINS VSS=DVSS VDD=DVDD
XFILLER_T_7_6 DCAP4 $PINS VSS=DVSS VDD=DVDD
XFILLER_T_6_7 DCAP32 $PINS VSS=DVSS VDD=DVDD
XFILLER_T_7_5 DCAP16 $PINS VSS=DVSS VDD=DVDD
XFILLER_T_6_6 DCAP4 $PINS VSS=DVSS VDD=DVDD
XFILLER_T_8_3 DCAP4 $PINS VSS=DVSS VDD=DVDD
XFILLER_T_6_5 DCAP16 $PINS VSS=DVSS VDD=DVDD
XFILLER_T_8_2 DCAP16 $PINS VSS=DVSS VDD=DVDD
XFILLER_T_9_3 DCAP4 $PINS VSS=DVSS VDD=DVDD
XFILLER_T_7_4 DCAP32 $PINS VSS=DVSS VDD=DVDD
XFILLER_T_6_4 DCAP32 $PINS VSS=DVSS VDD=DVDD
XFILLER_T_7_3 DCAP4 $PINS VSS=DVSS VDD=DVDD
XFILLER_T_6_3 DCAP4 $PINS VSS=DVSS VDD=DVDD
XFILLER_T_8_1 DCAP32 $PINS VSS=DVSS VDD=DVDD
XFILLER_T_9_2 DCAP16 $PINS VSS=DVSS VDD=DVDD
XFILLER_T_7_2 DCAP16 $PINS VSS=DVSS VDD=DVDD
XFILLER_T_6_2 DCAP16 $PINS VSS=DVSS VDD=DVDD
XFILLER_T_7_1 DCAP32 $PINS VSS=DVSS VDD=DVDD
XFILLER_T_9_1 DCAP32 $PINS VSS=DVSS VDD=DVDD
XFILLER_T_6_1 DCAP32 $PINS VSS=DVSS VDD=DVDD
XFILLER_T_1_202 DCAP4 $PINS VSS=DVSS VDD=DVDD
XFILLER_T_1_201 DCAP16 $PINS VSS=DVSS VDD=DVDD
XFILLER_T_1_200 DCAP32 $PINS VSS=DVSS VDD=DVDD
XFILLER_T_1_199 DCAP4 $PINS VSS=DVSS VDD=DVDD
XFILLER_T_1_198 DCAP16 $PINS VSS=DVSS VDD=DVDD
XFILLER_T_1_197 DCAP32 $PINS VSS=DVSS VDD=DVDD
XFILLER_T_1_196 DCAP4 $PINS VSS=DVSS VDD=DVDD
XFILLER_T_1_195 DCAP16 $PINS VSS=DVSS VDD=DVDD
XFILLER_T_1_194 DCAP32 $PINS VSS=DVSS VDD=DVDD
XFILLER_T_1_193 DCAP4 $PINS VSS=DVSS VDD=DVDD
XFILLER_T_1_192 DCAP16 $PINS VSS=DVSS VDD=DVDD
XFILLER_T_1_191 DCAP32 $PINS VSS=DVSS VDD=DVDD
XFILLER_T_1_190 DCAP4 $PINS VSS=DVSS VDD=DVDD
XFILLER_T_1_189 DCAP16 $PINS VSS=DVSS VDD=DVDD
XFILLER_T_1_188 DCAP32 $PINS VSS=DVSS VDD=DVDD
XFILLER_T_1_185 DCAP16 $PINS VSS=DVSS VDD=DVDD
XFILLER_T_1_183 DCAP4 $PINS VSS=DVSS VDD=DVDD
XFILLER_T_1_180 DCAP4 $PINS VSS=DVSS VDD=DVDD
XFILLER_T_1_175 DCAP8 $PINS VSS=DVSS VDD=DVDD
XFILLER_T_1_173 DCAP4 $PINS VSS=DVSS VDD=DVDD
XFILLER_T_1_171 DCAP4 $PINS VSS=DVSS VDD=DVDD
XFILLER_T_1_164 DCAP4 $PINS VSS=DVSS VDD=DVDD
XFILLER_T_1_158 DCAP4 $PINS VSS=DVSS VDD=DVDD
XFILLER_T_1_154 DCAP4 $PINS VSS=DVSS VDD=DVDD
XFILLER_T_1_153 DCAP8 $PINS VSS=DVSS VDD=DVDD
XFILLER_T_1_151 DCAP4 $PINS VSS=DVSS VDD=DVDD
XFILLER_T_1_150 DCAP4 $PINS VSS=DVSS VDD=DVDD
XFILLER_T_1_149 DCAP8 $PINS VSS=DVSS VDD=DVDD
XFILLER_T_1_147 DCAP4 $PINS VSS=DVSS VDD=DVDD
XFILLER_T_1_145 DCAP4 $PINS VSS=DVSS VDD=DVDD
XFILLER_T_1_144 DCAP8 $PINS VSS=DVSS VDD=DVDD
XFILLER_T_1_143 DCAP4 $PINS VSS=DVSS VDD=DVDD
XFILLER_T_1_142 DCAP4 $PINS VSS=DVSS VDD=DVDD
XFILLER_T_1_139 DCAP4 $PINS VSS=DVSS VDD=DVDD
XFILLER_T_1_136 DCAP4 $PINS VSS=DVSS VDD=DVDD
XFILLER_T_1_133 DCAP4 $PINS VSS=DVSS VDD=DVDD
XFILLER_T_1_130 DCAP4 $PINS VSS=DVSS VDD=DVDD
XFILLER_T_1_125 DCAP4 $PINS VSS=DVSS VDD=DVDD
XFILLER_T_1_87 DCAP4 $PINS VSS=DVSS VDD=DVDD
XFILLER_T_1_81 DCAP16 $PINS VSS=DVSS VDD=DVDD
XFILLER_T_3_150 DCAP4 $PINS VSS=DVSS VDD=DVDD
XFILLER_T_2_153 DCAP4 $PINS VSS=DVSS VDD=DVDD
XFILLER_T_3_149 DCAP16 $PINS VSS=DVSS VDD=DVDD
XFILLER_T_2_152 DCAP16 $PINS VSS=DVSS VDD=DVDD
XFILLER_T_3_148 DCAP32 $PINS VSS=DVSS VDD=DVDD
XFILLER_T_2_151 DCAP32 $PINS VSS=DVSS VDD=DVDD
XFILLER_T_3_147 DCAP4 $PINS VSS=DVSS VDD=DVDD
XFILLER_T_2_150 DCAP4 $PINS VSS=DVSS VDD=DVDD
XFILLER_T_4_150 DCAP4 $PINS VSS=DVSS VDD=DVDD
XFILLER_T_3_146 DCAP16 $PINS VSS=DVSS VDD=DVDD
XFILLER_T_2_149 DCAP16 $PINS VSS=DVSS VDD=DVDD
XFILLER_T_2_148 DCAP32 $PINS VSS=DVSS VDD=DVDD
XFILLER_T_4_149 DCAP16 $PINS VSS=DVSS VDD=DVDD
XFILLER_T_3_145 DCAP32 $PINS VSS=DVSS VDD=DVDD
XFILLER_T_2_147 DCAP4 $PINS VSS=DVSS VDD=DVDD
XFILLER_T_4_148 DCAP32 $PINS VSS=DVSS VDD=DVDD
XFILLER_T_3_144 DCAP4 $PINS VSS=DVSS VDD=DVDD
XFILLER_T_4_147 DCAP4 $PINS VSS=DVSS VDD=DVDD
XFILLER_T_2_146 DCAP16 $PINS VSS=DVSS VDD=DVDD
XFILLER_T_3_143 DCAP16 $PINS VSS=DVSS VDD=DVDD
XFILLER_T_2_145 DCAP32 $PINS VSS=DVSS VDD=DVDD
XFILLER_T_4_146 DCAP16 $PINS VSS=DVSS VDD=DVDD
XFILLER_T_3_142 DCAP32 $PINS VSS=DVSS VDD=DVDD
XFILLER_T_2_144 DCAP4 $PINS VSS=DVSS VDD=DVDD
XFILLER_T_4_145 DCAP32 $PINS VSS=DVSS VDD=DVDD
XFILLER_T_3_141 DCAP4 $PINS VSS=DVSS VDD=DVDD
XFILLER_T_2_143 DCAP16 $PINS VSS=DVSS VDD=DVDD
XFILLER_T_4_144 DCAP4 $PINS VSS=DVSS VDD=DVDD
XFILLER_T_3_140 DCAP16 $PINS VSS=DVSS VDD=DVDD
XFILLER_T_2_142 DCAP32 $PINS VSS=DVSS VDD=DVDD
XFILLER_T_4_143 DCAP16 $PINS VSS=DVSS VDD=DVDD
XFILLER_T_3_139 DCAP32 $PINS VSS=DVSS VDD=DVDD
XFILLER_T_2_141 DCAP4 $PINS VSS=DVSS VDD=DVDD
XFILLER_T_4_142 DCAP32 $PINS VSS=DVSS VDD=DVDD
XFILLER_T_3_138 DCAP4 $PINS VSS=DVSS VDD=DVDD
XFILLER_T_4_141 DCAP4 $PINS VSS=DVSS VDD=DVDD
XFILLER_T_2_140 DCAP16 $PINS VSS=DVSS VDD=DVDD
XFILLER_T_4_140 DCAP16 $PINS VSS=DVSS VDD=DVDD
XFILLER_T_3_137 DCAP16 $PINS VSS=DVSS VDD=DVDD
XFILLER_T_4_139 DCAP32 $PINS VSS=DVSS VDD=DVDD
XFILLER_T_2_139 DCAP32 $PINS VSS=DVSS VDD=DVDD
XFILLER_T_3_136 DCAP32 $PINS VSS=DVSS VDD=DVDD
XFILLER_T_4_138 DCAP4 $PINS VSS=DVSS VDD=DVDD
XFILLER_T_2_138 DCAP4 $PINS VSS=DVSS VDD=DVDD
XFILLER_T_1_67 DCAP16 $PINS VSS=DVSS VDD=DVDD
XFILLER_T_3_135 DCAP4 $PINS VSS=DVSS VDD=DVDD
XFILLER_T_4_137 DCAP16 $PINS VSS=DVSS VDD=DVDD
XFILLER_T_2_137 DCAP16 $PINS VSS=DVSS VDD=DVDD
XFILLER_T_3_134 DCAP16 $PINS VSS=DVSS VDD=DVDD
XFILLER_T_4_136 DCAP32 $PINS VSS=DVSS VDD=DVDD
XFILLER_T_2_136 DCAP32 $PINS VSS=DVSS VDD=DVDD
XFILLER_T_3_133 DCAP32 $PINS VSS=DVSS VDD=DVDD
XFILLER_T_2_135 DCAP4 $PINS VSS=DVSS VDD=DVDD
XFILLER_T_4_135 DCAP4 $PINS VSS=DVSS VDD=DVDD
XFILLER_T_3_132 DCAP4 $PINS VSS=DVSS VDD=DVDD
XFILLER_T_4_134 DCAP16 $PINS VSS=DVSS VDD=DVDD
XFILLER_T_3_131 DCAP16 $PINS VSS=DVSS VDD=DVDD
XFILLER_T_4_133 DCAP32 $PINS VSS=DVSS VDD=DVDD
XFILLER_T_2_134 DCAP16 $PINS VSS=DVSS VDD=DVDD
XFILLER_T_4_132 DCAP4 $PINS VSS=DVSS VDD=DVDD
XFILLER_T_2_133 DCAP32 $PINS VSS=DVSS VDD=DVDD
XFILLER_T_4_131 DCAP16 $PINS VSS=DVSS VDD=DVDD
XFILLER_T_2_132 DCAP4 $PINS VSS=DVSS VDD=DVDD
XFILLER_T_4_130 DCAP32 $PINS VSS=DVSS VDD=DVDD
XFILLER_T_2_131 DCAP16 $PINS VSS=DVSS VDD=DVDD
XFILLER_T_4_129 DCAP4 $PINS VSS=DVSS VDD=DVDD
XFILLER_T_3_130 DCAP32 $PINS VSS=DVSS VDD=DVDD
XFILLER_T_2_130 DCAP32 $PINS VSS=DVSS VDD=DVDD
XFILLER_T_3_129 DCAP4 $PINS VSS=DVSS VDD=DVDD
XFILLER_T_2_129 DCAP4 $PINS VSS=DVSS VDD=DVDD
XFILLER_T_3_128 DCAP16 $PINS VSS=DVSS VDD=DVDD
XFILLER_T_2_128 DCAP16 $PINS VSS=DVSS VDD=DVDD
XFILLER_T_3_127 DCAP32 $PINS VSS=DVSS VDD=DVDD
XFILLER_T_2_127 DCAP32 $PINS VSS=DVSS VDD=DVDD
XFILLER_T_3_126 DCAP4 $PINS VSS=DVSS VDD=DVDD
XFILLER_T_4_128 DCAP16 $PINS VSS=DVSS VDD=DVDD
XFILLER_T_2_126 DCAP4 $PINS VSS=DVSS VDD=DVDD
XFILLER_T_3_125 DCAP16 $PINS VSS=DVSS VDD=DVDD
XFILLER_T_4_127 DCAP32 $PINS VSS=DVSS VDD=DVDD
XFILLER_T_2_125 DCAP16 $PINS VSS=DVSS VDD=DVDD
XFILLER_T_3_124 DCAP32 $PINS VSS=DVSS VDD=DVDD
XFILLER_T_4_126 DCAP4 $PINS VSS=DVSS VDD=DVDD
XFILLER_T_2_124 DCAP32 $PINS VSS=DVSS VDD=DVDD
XFILLER_T_4_125 DCAP16 $PINS VSS=DVSS VDD=DVDD
XFILLER_T_2_123 DCAP4 $PINS VSS=DVSS VDD=DVDD
XFILLER_T_3_123 DCAP4 $PINS VSS=DVSS VDD=DVDD
XFILLER_T_4_124 DCAP32 $PINS VSS=DVSS VDD=DVDD
XFILLER_T_2_122 DCAP16 $PINS VSS=DVSS VDD=DVDD
XFILLER_T_4_123 DCAP4 $PINS VSS=DVSS VDD=DVDD
XFILLER_T_3_122 DCAP16 $PINS VSS=DVSS VDD=DVDD
XFILLER_T_2_121 DCAP32 $PINS VSS=DVSS VDD=DVDD
XFILLER_T_4_122 DCAP16 $PINS VSS=DVSS VDD=DVDD
XFILLER_T_3_121 DCAP32 $PINS VSS=DVSS VDD=DVDD
XFILLER_T_2_120 DCAP4 $PINS VSS=DVSS VDD=DVDD
XFILLER_T_4_121 DCAP32 $PINS VSS=DVSS VDD=DVDD
XFILLER_T_3_120 DCAP4 $PINS VSS=DVSS VDD=DVDD
XFILLER_T_4_120 DCAP4 $PINS VSS=DVSS VDD=DVDD
XFILLER_T_2_119 DCAP16 $PINS VSS=DVSS VDD=DVDD
XFILLER_T_3_119 DCAP16 $PINS VSS=DVSS VDD=DVDD
XFILLER_T_4_119 DCAP16 $PINS VSS=DVSS VDD=DVDD
XFILLER_T_2_118 DCAP32 $PINS VSS=DVSS VDD=DVDD
XFILLER_T_3_118 DCAP32 $PINS VSS=DVSS VDD=DVDD
XFILLER_T_4_118 DCAP32 $PINS VSS=DVSS VDD=DVDD
XFILLER_T_2_117 DCAP4 $PINS VSS=DVSS VDD=DVDD
XFILLER_T_3_117 DCAP4 $PINS VSS=DVSS VDD=DVDD
XFILLER_T_2_116 DCAP16 $PINS VSS=DVSS VDD=DVDD
XFILLER_T_3_116 DCAP16 $PINS VSS=DVSS VDD=DVDD
XFILLER_T_2_115 DCAP32 $PINS VSS=DVSS VDD=DVDD
XFILLER_T_3_115 DCAP32 $PINS VSS=DVSS VDD=DVDD
XFILLER_T_2_114 DCAP4 $PINS VSS=DVSS VDD=DVDD
XFILLER_T_3_114 DCAP4 $PINS VSS=DVSS VDD=DVDD
XFILLER_T_4_117 DCAP4 $PINS VSS=DVSS VDD=DVDD
XFILLER_T_2_113 DCAP16 $PINS VSS=DVSS VDD=DVDD
XFILLER_T_2_112 DCAP32 $PINS VSS=DVSS VDD=DVDD
XFILLER_T_4_116 DCAP16 $PINS VSS=DVSS VDD=DVDD
XFILLER_T_3_113 DCAP16 $PINS VSS=DVSS VDD=DVDD
XFILLER_T_2_111 DCAP4 $PINS VSS=DVSS VDD=DVDD
XFILLER_T_4_115 DCAP32 $PINS VSS=DVSS VDD=DVDD
XFILLER_T_3_112 DCAP32 $PINS VSS=DVSS VDD=DVDD
XFILLER_T_2_110 DCAP16 $PINS VSS=DVSS VDD=DVDD
XFILLER_T_3_111 DCAP4 $PINS VSS=DVSS VDD=DVDD
XFILLER_T_4_114 DCAP4 $PINS VSS=DVSS VDD=DVDD
XFILLER_T_2_109 DCAP32 $PINS VSS=DVSS VDD=DVDD
XFILLER_T_2_108 DCAP4 $PINS VSS=DVSS VDD=DVDD
XFILLER_T_3_110 DCAP16 $PINS VSS=DVSS VDD=DVDD
XFILLER_T_4_113 DCAP16 $PINS VSS=DVSS VDD=DVDD
XFILLER_T_3_109 DCAP32 $PINS VSS=DVSS VDD=DVDD
XFILLER_T_2_107 DCAP16 $PINS VSS=DVSS VDD=DVDD
XFILLER_T_4_112 DCAP32 $PINS VSS=DVSS VDD=DVDD
XFILLER_T_3_108 DCAP4 $PINS VSS=DVSS VDD=DVDD
XFILLER_T_4_111 DCAP4 $PINS VSS=DVSS VDD=DVDD
XFILLER_T_2_106 DCAP32 $PINS VSS=DVSS VDD=DVDD
XFILLER_T_4_110 DCAP16 $PINS VSS=DVSS VDD=DVDD
XFILLER_T_2_105 DCAP4 $PINS VSS=DVSS VDD=DVDD
XFILLER_T_3_107 DCAP16 $PINS VSS=DVSS VDD=DVDD
XFILLER_T_4_109 DCAP32 $PINS VSS=DVSS VDD=DVDD
XFILLER_T_2_104 DCAP16 $PINS VSS=DVSS VDD=DVDD
XFILLER_T_4_108 DCAP4 $PINS VSS=DVSS VDD=DVDD
XFILLER_T_2_103 DCAP32 $PINS VSS=DVSS VDD=DVDD
XFILLER_T_4_107 DCAP16 $PINS VSS=DVSS VDD=DVDD
XFILLER_T_2_102 DCAP4 $PINS VSS=DVSS VDD=DVDD
XFILLER_T_4_106 DCAP32 $PINS VSS=DVSS VDD=DVDD
XFILLER_T_2_101 DCAP16 $PINS VSS=DVSS VDD=DVDD
XFILLER_T_4_105 DCAP4 $PINS VSS=DVSS VDD=DVDD
XFILLER_T_3_106 DCAP32 $PINS VSS=DVSS VDD=DVDD
XFILLER_T_4_104 DCAP16 $PINS VSS=DVSS VDD=DVDD
XFILLER_T_2_100 DCAP32 $PINS VSS=DVSS VDD=DVDD
XFILLER_T_3_105 DCAP4 $PINS VSS=DVSS VDD=DVDD
XFILLER_T_2_99 DCAP4 $PINS VSS=DVSS VDD=DVDD
XFILLER_T_4_103 DCAP32 $PINS VSS=DVSS VDD=DVDD
XFILLER_T_3_104 DCAP16 $PINS VSS=DVSS VDD=DVDD
XFILLER_T_4_102 DCAP4 $PINS VSS=DVSS VDD=DVDD
XFILLER_T_2_98 DCAP16 $PINS VSS=DVSS VDD=DVDD
XFILLER_T_3_103 DCAP32 $PINS VSS=DVSS VDD=DVDD
XFILLER_T_4_101 DCAP16 $PINS VSS=DVSS VDD=DVDD
XFILLER_T_3_102 DCAP4 $PINS VSS=DVSS VDD=DVDD
XFILLER_T_4_100 DCAP32 $PINS VSS=DVSS VDD=DVDD
XFILLER_T_3_101 DCAP16 $PINS VSS=DVSS VDD=DVDD
XFILLER_T_4_99 DCAP4 $PINS VSS=DVSS VDD=DVDD
XFILLER_T_4_98 DCAP16 $PINS VSS=DVSS VDD=DVDD
XFILLER_T_2_97 DCAP32 $PINS VSS=DVSS VDD=DVDD
XFILLER_T_3_100 DCAP32 $PINS VSS=DVSS VDD=DVDD
XFILLER_T_3_99 DCAP4 $PINS VSS=DVSS VDD=DVDD
XFILLER_T_4_97 DCAP32 $PINS VSS=DVSS VDD=DVDD
XFILLER_T_3_98 DCAP16 $PINS VSS=DVSS VDD=DVDD
XFILLER_T_4_96 DCAP4 $PINS VSS=DVSS VDD=DVDD
XFILLER_T_2_96 DCAP4 $PINS VSS=DVSS VDD=DVDD
XFILLER_T_3_97 DCAP32 $PINS VSS=DVSS VDD=DVDD
XFILLER_T_2_95 DCAP16 $PINS VSS=DVSS VDD=DVDD
XFILLER_T_3_96 DCAP4 $PINS VSS=DVSS VDD=DVDD
XFILLER_T_4_95 DCAP16 $PINS VSS=DVSS VDD=DVDD
XFILLER_T_2_94 DCAP32 $PINS VSS=DVSS VDD=DVDD
XFILLER_T_3_95 DCAP16 $PINS VSS=DVSS VDD=DVDD
XFILLER_T_4_94 DCAP32 $PINS VSS=DVSS VDD=DVDD
XFILLER_T_2_93 DCAP4 $PINS VSS=DVSS VDD=DVDD
XFILLER_T_4_93 DCAP4 $PINS VSS=DVSS VDD=DVDD
XFILLER_T_3_94 DCAP32 $PINS VSS=DVSS VDD=DVDD
XFILLER_T_2_92 DCAP16 $PINS VSS=DVSS VDD=DVDD
XFILLER_T_4_92 DCAP16 $PINS VSS=DVSS VDD=DVDD
XFILLER_T_3_93 DCAP4 $PINS VSS=DVSS VDD=DVDD
XFILLER_T_4_91 DCAP32 $PINS VSS=DVSS VDD=DVDD
XFILLER_T_3_92 DCAP16 $PINS VSS=DVSS VDD=DVDD
XFILLER_T_4_90 DCAP4 $PINS VSS=DVSS VDD=DVDD
XFILLER_T_3_91 DCAP32 $PINS VSS=DVSS VDD=DVDD
XFILLER_T_4_89 DCAP16 $PINS VSS=DVSS VDD=DVDD
XFILLER_T_3_90 DCAP4 $PINS VSS=DVSS VDD=DVDD
XFILLER_T_4_88 DCAP32 $PINS VSS=DVSS VDD=DVDD
XFILLER_T_2_91 DCAP32 $PINS VSS=DVSS VDD=DVDD
XFILLER_T_3_89 DCAP16 $PINS VSS=DVSS VDD=DVDD
XFILLER_T_2_90 DCAP4 $PINS VSS=DVSS VDD=DVDD
XFILLER_T_4_87 DCAP4 $PINS VSS=DVSS VDD=DVDD
XFILLER_T_3_88 DCAP32 $PINS VSS=DVSS VDD=DVDD
XFILLER_T_3_87 DCAP4 $PINS VSS=DVSS VDD=DVDD
XFILLER_T_2_89 DCAP16 $PINS VSS=DVSS VDD=DVDD
XFILLER_T_4_86 DCAP16 $PINS VSS=DVSS VDD=DVDD
XFILLER_T_3_86 DCAP16 $PINS VSS=DVSS VDD=DVDD
XFILLER_T_2_88 DCAP32 $PINS VSS=DVSS VDD=DVDD
XFILLER_T_3_85 DCAP32 $PINS VSS=DVSS VDD=DVDD
XFILLER_T_2_87 DCAP4 $PINS VSS=DVSS VDD=DVDD
XFILLER_T_4_85 DCAP32 $PINS VSS=DVSS VDD=DVDD
XFILLER_T_4_84 DCAP4 $PINS VSS=DVSS VDD=DVDD
XFILLER_T_3_84 DCAP4 $PINS VSS=DVSS VDD=DVDD
XFILLER_T_2_86 DCAP16 $PINS VSS=DVSS VDD=DVDD
XFILLER_T_4_83 DCAP16 $PINS VSS=DVSS VDD=DVDD
XFILLER_T_3_83 DCAP16 $PINS VSS=DVSS VDD=DVDD
XFILLER_T_2_85 DCAP32 $PINS VSS=DVSS VDD=DVDD
XFILLER_T_2_84 DCAP4 $PINS VSS=DVSS VDD=DVDD
XFILLER_T_4_82 DCAP32 $PINS VSS=DVSS VDD=DVDD
XFILLER_T_4_81 DCAP4 $PINS VSS=DVSS VDD=DVDD
XFILLER_T_3_82 DCAP32 $PINS VSS=DVSS VDD=DVDD
XFILLER_T_2_83 DCAP16 $PINS VSS=DVSS VDD=DVDD
XFILLER_T_3_81 DCAP4 $PINS VSS=DVSS VDD=DVDD
XFILLER_T_4_80 DCAP16 $PINS VSS=DVSS VDD=DVDD
XFILLER_T_2_82 DCAP32 $PINS VSS=DVSS VDD=DVDD
XFILLER_T_3_80 DCAP16 $PINS VSS=DVSS VDD=DVDD
XFILLER_T_4_79 DCAP32 $PINS VSS=DVSS VDD=DVDD
XFILLER_T_2_81 DCAP4 $PINS VSS=DVSS VDD=DVDD
XFILLER_T_3_79 DCAP32 $PINS VSS=DVSS VDD=DVDD
XFILLER_T_3_78 DCAP4 $PINS VSS=DVSS VDD=DVDD
XFILLER_T_4_78 DCAP4 $PINS VSS=DVSS VDD=DVDD
XFILLER_T_2_80 DCAP16 $PINS VSS=DVSS VDD=DVDD
XFILLER_T_3_77 DCAP16 $PINS VSS=DVSS VDD=DVDD
XFILLER_T_2_79 DCAP32 $PINS VSS=DVSS VDD=DVDD
XFILLER_T_4_77 DCAP16 $PINS VSS=DVSS VDD=DVDD
XFILLER_T_3_76 DCAP32 $PINS VSS=DVSS VDD=DVDD
XFILLER_T_2_78 DCAP4 $PINS VSS=DVSS VDD=DVDD
XFILLER_T_4_76 DCAP32 $PINS VSS=DVSS VDD=DVDD
XFILLER_T_3_75 DCAP4 $PINS VSS=DVSS VDD=DVDD
XFILLER_T_2_77 DCAP16 $PINS VSS=DVSS VDD=DVDD
XFILLER_T_4_75 DCAP4 $PINS VSS=DVSS VDD=DVDD
XFILLER_T_2_76 DCAP32 $PINS VSS=DVSS VDD=DVDD
XFILLER_T_4_74 DCAP16 $PINS VSS=DVSS VDD=DVDD
XFILLER_T_3_74 DCAP16 $PINS VSS=DVSS VDD=DVDD
XFILLER_T_4_73 DCAP32 $PINS VSS=DVSS VDD=DVDD
XFILLER_T_2_75 DCAP4 $PINS VSS=DVSS VDD=DVDD
XFILLER_T_3_73 DCAP32 $PINS VSS=DVSS VDD=DVDD
XFILLER_T_2_74 DCAP16 $PINS VSS=DVSS VDD=DVDD
XFILLER_T_3_72 DCAP4 $PINS VSS=DVSS VDD=DVDD
XFILLER_T_4_72 DCAP4 $PINS VSS=DVSS VDD=DVDD
XFILLER_T_2_73 DCAP32 $PINS VSS=DVSS VDD=DVDD
XFILLER_T_3_71 DCAP16 $PINS VSS=DVSS VDD=DVDD
XFILLER_T_3_70 DCAP32 $PINS VSS=DVSS VDD=DVDD
XFILLER_T_4_71 DCAP16 $PINS VSS=DVSS VDD=DVDD
XFILLER_T_3_69 DCAP4 $PINS VSS=DVSS VDD=DVDD
XFILLER_T_2_72 DCAP4 $PINS VSS=DVSS VDD=DVDD
XFILLER_T_3_68 DCAP16 $PINS VSS=DVSS VDD=DVDD
XFILLER_T_2_71 DCAP16 $PINS VSS=DVSS VDD=DVDD
XFILLER_T_3_67 DCAP32 $PINS VSS=DVSS VDD=DVDD
XFILLER_T_2_70 DCAP32 $PINS VSS=DVSS VDD=DVDD
XFILLER_T_3_66 DCAP4 $PINS VSS=DVSS VDD=DVDD
XFILLER_T_2_69 DCAP4 $PINS VSS=DVSS VDD=DVDD
XFILLER_T_3_65 DCAP16 $PINS VSS=DVSS VDD=DVDD
XFILLER_T_2_68 DCAP16 $PINS VSS=DVSS VDD=DVDD
XFILLER_T_3_64 DCAP32 $PINS VSS=DVSS VDD=DVDD
XFILLER_T_3_63 DCAP4 $PINS VSS=DVSS VDD=DVDD
XFILLER_T_2_67 DCAP32 $PINS VSS=DVSS VDD=DVDD
XFILLER_T_4_70 DCAP32 $PINS VSS=DVSS VDD=DVDD
XFILLER_T_2_66 DCAP4 $PINS VSS=DVSS VDD=DVDD
XFILLER_T_4_69 DCAP4 $PINS VSS=DVSS VDD=DVDD
XFILLER_T_3_62 DCAP16 $PINS VSS=DVSS VDD=DVDD
XFILLER_T_1_30 DCAP8 $PINS VSS=DVSS VDD=DVDD
XFILLER_T_3_61 DCAP32 $PINS VSS=DVSS VDD=DVDD
XFILLER_T_2_65 DCAP16 $PINS VSS=DVSS VDD=DVDD
XFILLER_T_3_60 DCAP4 $PINS VSS=DVSS VDD=DVDD
XFILLER_T_1_29 DCAP4 $PINS VSS=DVSS VDD=DVDD
XFILLER_T_4_68 DCAP16 $PINS VSS=DVSS VDD=DVDD
XFILLER_T_2_64 DCAP32 $PINS VSS=DVSS VDD=DVDD
XFILLER_T_3_59 DCAP16 $PINS VSS=DVSS VDD=DVDD
XFILLER_T_4_67 DCAP32 $PINS VSS=DVSS VDD=DVDD
XFILLER_T_2_63 DCAP4 $PINS VSS=DVSS VDD=DVDD
XFILLER_T_3_58 DCAP32 $PINS VSS=DVSS VDD=DVDD
XFILLER_T_4_66 DCAP4 $PINS VSS=DVSS VDD=DVDD
XFILLER_T_2_62 DCAP16 $PINS VSS=DVSS VDD=DVDD
XFILLER_T_3_57 DCAP4 $PINS VSS=DVSS VDD=DVDD
XFILLER_T_4_65 DCAP16 $PINS VSS=DVSS VDD=DVDD
XFILLER_T_2_61 DCAP32 $PINS VSS=DVSS VDD=DVDD
XFILLER_T_3_56 DCAP16 $PINS VSS=DVSS VDD=DVDD
XFILLER_T_4_64 DCAP32 $PINS VSS=DVSS VDD=DVDD
XFILLER_T_3_55 DCAP32 $PINS VSS=DVSS VDD=DVDD
XFILLER_T_4_63 DCAP4 $PINS VSS=DVSS VDD=DVDD
XFILLER_T_3_54 DCAP4 $PINS VSS=DVSS VDD=DVDD
XFILLER_T_4_62 DCAP16 $PINS VSS=DVSS VDD=DVDD
XFILLER_T_2_60 DCAP4 $PINS VSS=DVSS VDD=DVDD
XFILLER_T_3_53 DCAP16 $PINS VSS=DVSS VDD=DVDD
XFILLER_T_4_61 DCAP32 $PINS VSS=DVSS VDD=DVDD
XFILLER_T_2_59 DCAP16 $PINS VSS=DVSS VDD=DVDD
XFILLER_T_3_52 DCAP32 $PINS VSS=DVSS VDD=DVDD
XFILLER_T_4_60 DCAP4 $PINS VSS=DVSS VDD=DVDD
XFILLER_T_2_58 DCAP32 $PINS VSS=DVSS VDD=DVDD
XFILLER_T_3_51 DCAP4 $PINS VSS=DVSS VDD=DVDD
XFILLER_T_4_59 DCAP16 $PINS VSS=DVSS VDD=DVDD
XFILLER_T_2_57 DCAP4 $PINS VSS=DVSS VDD=DVDD
XFILLER_T_3_50 DCAP16 $PINS VSS=DVSS VDD=DVDD
XFILLER_T_4_58 DCAP32 $PINS VSS=DVSS VDD=DVDD
XFILLER_T_2_56 DCAP16 $PINS VSS=DVSS VDD=DVDD
XFILLER_T_3_49 DCAP32 $PINS VSS=DVSS VDD=DVDD
XFILLER_T_4_57 DCAP4 $PINS VSS=DVSS VDD=DVDD
XFILLER_T_3_48 DCAP4 $PINS VSS=DVSS VDD=DVDD
XFILLER_T_2_55 DCAP32 $PINS VSS=DVSS VDD=DVDD
XFILLER_T_2_54 DCAP4 $PINS VSS=DVSS VDD=DVDD
XFILLER_T_4_56 DCAP16 $PINS VSS=DVSS VDD=DVDD
XFILLER_T_3_47 DCAP16 $PINS VSS=DVSS VDD=DVDD
XFILLER_T_2_53 DCAP16 $PINS VSS=DVSS VDD=DVDD
XFILLER_T_4_55 DCAP32 $PINS VSS=DVSS VDD=DVDD
XFILLER_T_3_46 DCAP32 $PINS VSS=DVSS VDD=DVDD
XFILLER_T_2_52 DCAP32 $PINS VSS=DVSS VDD=DVDD
XFILLER_T_4_54 DCAP4 $PINS VSS=DVSS VDD=DVDD
XFILLER_T_3_45 DCAP4 $PINS VSS=DVSS VDD=DVDD
XFILLER_T_4_53 DCAP16 $PINS VSS=DVSS VDD=DVDD
XFILLER_T_2_50 DCAP4 $PINS VSS=DVSS VDD=DVDD
XFILLER_T_3_44 DCAP16 $PINS VSS=DVSS VDD=DVDD
XFILLER_T_4_52 DCAP32 $PINS VSS=DVSS VDD=DVDD
XFILLER_T_4_51 DCAP4 $PINS VSS=DVSS VDD=DVDD
XFILLER_T_2_49 DCAP32 $PINS VSS=DVSS VDD=DVDD
XFILLER_T_3_43 DCAP32 $PINS VSS=DVSS VDD=DVDD
XFILLER_T_4_50 DCAP16 $PINS VSS=DVSS VDD=DVDD
XFILLER_T_3_42 DCAP4 $PINS VSS=DVSS VDD=DVDD
XFILLER_T_4_49 DCAP32 $PINS VSS=DVSS VDD=DVDD
XFILLER_T_3_41 DCAP16 $PINS VSS=DVSS VDD=DVDD
XFILLER_T_4_48 DCAP4 $PINS VSS=DVSS VDD=DVDD
XFILLER_T_3_40 DCAP32 $PINS VSS=DVSS VDD=DVDD
XFILLER_T_4_47 DCAP16 $PINS VSS=DVSS VDD=DVDD
XFILLER_T_3_39 DCAP4 $PINS VSS=DVSS VDD=DVDD
XFILLER_T_4_46 DCAP32 $PINS VSS=DVSS VDD=DVDD
XFILLER_T_3_38 DCAP16 $PINS VSS=DVSS VDD=DVDD
XFILLER_T_4_45 DCAP4 $PINS VSS=DVSS VDD=DVDD
XFILLER_T_3_37 DCAP32 $PINS VSS=DVSS VDD=DVDD
XFILLER_T_4_44 DCAP16 $PINS VSS=DVSS VDD=DVDD
XFILLER_T_2_46 DCAP8 $PINS VSS=DVSS VDD=DVDD
XFILLER_T_4_43 DCAP32 $PINS VSS=DVSS VDD=DVDD
XFILLER_T_2_45 DCAP4 $PINS VSS=DVSS VDD=DVDD
XFILLER_T_3_36 DCAP4 $PINS VSS=DVSS VDD=DVDD
XFILLER_T_4_42 DCAP4 $PINS VSS=DVSS VDD=DVDD
XFILLER_T_2_44 DCAP16 $PINS VSS=DVSS VDD=DVDD
XFILLER_T_3_35 DCAP16 $PINS VSS=DVSS VDD=DVDD
XFILLER_T_2_43 DCAP32 $PINS VSS=DVSS VDD=DVDD
XFILLER_T_3_34 DCAP32 $PINS VSS=DVSS VDD=DVDD
XFILLER_T_2_42 DCAP4 $PINS VSS=DVSS VDD=DVDD
XFILLER_T_3_33 DCAP4 $PINS VSS=DVSS VDD=DVDD
XFILLER_T_2_41 DCAP16 $PINS VSS=DVSS VDD=DVDD
XFILLER_T_3_32 DCAP16 $PINS VSS=DVSS VDD=DVDD
XFILLER_T_2_40 DCAP32 $PINS VSS=DVSS VDD=DVDD
XFILLER_T_3_31 DCAP32 $PINS VSS=DVSS VDD=DVDD
XFILLER_T_2_39 DCAP4 $PINS VSS=DVSS VDD=DVDD
XFILLER_T_3_30 DCAP4 $PINS VSS=DVSS VDD=DVDD
XFILLER_T_2_38 DCAP16 $PINS VSS=DVSS VDD=DVDD
XFILLER_T_3_29 DCAP16 $PINS VSS=DVSS VDD=DVDD
XFILLER_T_2_37 DCAP32 $PINS VSS=DVSS VDD=DVDD
XFILLER_T_3_28 DCAP32 $PINS VSS=DVSS VDD=DVDD
XFILLER_T_2_36 DCAP4 $PINS VSS=DVSS VDD=DVDD
XFILLER_T_4_41 DCAP16 $PINS VSS=DVSS VDD=DVDD
XFILLER_T_3_27 DCAP4 $PINS VSS=DVSS VDD=DVDD
XFILLER_T_4_40 DCAP32 $PINS VSS=DVSS VDD=DVDD
XFILLER_T_3_26 DCAP16 $PINS VSS=DVSS VDD=DVDD
XFILLER_T_4_39 DCAP4 $PINS VSS=DVSS VDD=DVDD
XFILLER_T_2_35 DCAP16 $PINS VSS=DVSS VDD=DVDD
XFILLER_T_3_25 DCAP32 $PINS VSS=DVSS VDD=DVDD
XFILLER_T_4_38 DCAP16 $PINS VSS=DVSS VDD=DVDD
XFILLER_T_3_24 DCAP4 $PINS VSS=DVSS VDD=DVDD
XFILLER_T_4_37 DCAP32 $PINS VSS=DVSS VDD=DVDD
XFILLER_T_3_23 DCAP16 $PINS VSS=DVSS VDD=DVDD
XFILLER_T_4_36 DCAP4 $PINS VSS=DVSS VDD=DVDD
XFILLER_T_3_22 DCAP32 $PINS VSS=DVSS VDD=DVDD
XFILLER_T_4_35 DCAP16 $PINS VSS=DVSS VDD=DVDD
XFILLER_T_1_13 DCAP4 $PINS VSS=DVSS VDD=DVDD
XFILLER_T_2_34 DCAP32 $PINS VSS=DVSS VDD=DVDD
XFILLER_T_3_21 DCAP4 $PINS VSS=DVSS VDD=DVDD
XFILLER_T_4_34 DCAP32 $PINS VSS=DVSS VDD=DVDD
XFILLER_T_2_33 DCAP4 $PINS VSS=DVSS VDD=DVDD
XFILLER_T_3_20 DCAP16 $PINS VSS=DVSS VDD=DVDD
XFILLER_T_1_12 DCAP8 $PINS VSS=DVSS VDD=DVDD
XFILLER_T_4_33 DCAP4 $PINS VSS=DVSS VDD=DVDD
XFILLER_T_2_32 DCAP16 $PINS VSS=DVSS VDD=DVDD
XFILLER_T_4_32 DCAP16 $PINS VSS=DVSS VDD=DVDD
XFILLER_T_2_31 DCAP32 $PINS VSS=DVSS VDD=DVDD
XFILLER_T_4_31 DCAP32 $PINS VSS=DVSS VDD=DVDD
XFILLER_T_2_30 DCAP4 $PINS VSS=DVSS VDD=DVDD
XFILLER_T_3_19 DCAP32 $PINS VSS=DVSS VDD=DVDD
XFILLER_T_4_30 DCAP4 $PINS VSS=DVSS VDD=DVDD
XFILLER_T_3_18 DCAP4 $PINS VSS=DVSS VDD=DVDD
XFILLER_T_2_29 DCAP16 $PINS VSS=DVSS VDD=DVDD
XFILLER_T_2_28 DCAP32 $PINS VSS=DVSS VDD=DVDD
XFILLER_T_3_17 DCAP16 $PINS VSS=DVSS VDD=DVDD
XFILLER_T_4_29 DCAP16 $PINS VSS=DVSS VDD=DVDD
XFILLER_T_3_16 DCAP32 $PINS VSS=DVSS VDD=DVDD
XFILLER_T_4_28 DCAP32 $PINS VSS=DVSS VDD=DVDD
XFILLER_T_3_15 DCAP4 $PINS VSS=DVSS VDD=DVDD
XFILLER_T_4_27 DCAP4 $PINS VSS=DVSS VDD=DVDD
XFILLER_T_3_14 DCAP16 $PINS VSS=DVSS VDD=DVDD
XFILLER_T_2_27 DCAP4 $PINS VSS=DVSS VDD=DVDD
XFILLER_T_4_26 DCAP16 $PINS VSS=DVSS VDD=DVDD
XFILLER_T_2_26 DCAP16 $PINS VSS=DVSS VDD=DVDD
XFILLER_T_4_25 DCAP32 $PINS VSS=DVSS VDD=DVDD
XFILLER_T_2_25 DCAP32 $PINS VSS=DVSS VDD=DVDD
XFILLER_T_4_24 DCAP4 $PINS VSS=DVSS VDD=DVDD
XFILLER_T_2_24 DCAP4 $PINS VSS=DVSS VDD=DVDD
XFILLER_T_4_23 DCAP16 $PINS VSS=DVSS VDD=DVDD
XFILLER_T_3_13 DCAP32 $PINS VSS=DVSS VDD=DVDD
XFILLER_T_3_12 DCAP4 $PINS VSS=DVSS VDD=DVDD
XFILLER_T_2_23 DCAP16 $PINS VSS=DVSS VDD=DVDD
XFILLER_T_4_22 DCAP32 $PINS VSS=DVSS VDD=DVDD
XFILLER_T_3_11 DCAP16 $PINS VSS=DVSS VDD=DVDD
XFILLER_T_2_22 DCAP32 $PINS VSS=DVSS VDD=DVDD
XFILLER_T_4_21 DCAP4 $PINS VSS=DVSS VDD=DVDD
XFILLER_T_2_21 DCAP4 $PINS VSS=DVSS VDD=DVDD
XFILLER_T_3_10 DCAP32 $PINS VSS=DVSS VDD=DVDD
XFILLER_T_3_9 DCAP4 $PINS VSS=DVSS VDD=DVDD
XFILLER_T_4_20 DCAP16 $PINS VSS=DVSS VDD=DVDD
XFILLER_T_2_20 DCAP16 $PINS VSS=DVSS VDD=DVDD
XFILLER_T_3_8 DCAP16 $PINS VSS=DVSS VDD=DVDD
XFILLER_T_4_19 DCAP32 $PINS VSS=DVSS VDD=DVDD
XFILLER_T_2_19 DCAP32 $PINS VSS=DVSS VDD=DVDD
XFILLER_T_4_18 DCAP4 $PINS VSS=DVSS VDD=DVDD
XFILLER_T_2_18 DCAP4 $PINS VSS=DVSS VDD=DVDD
XFILLER_T_4_17 DCAP16 $PINS VSS=DVSS VDD=DVDD
XFILLER_T_2_17 DCAP16 $PINS VSS=DVSS VDD=DVDD
XFILLER_T_4_16 DCAP32 $PINS VSS=DVSS VDD=DVDD
XFILLER_T_2_16 DCAP32 $PINS VSS=DVSS VDD=DVDD
XFILLER_T_4_15 DCAP4 $PINS VSS=DVSS VDD=DVDD
XFILLER_T_2_15 DCAP4 $PINS VSS=DVSS VDD=DVDD
XFILLER_T_4_14 DCAP16 $PINS VSS=DVSS VDD=DVDD
XFILLER_T_2_14 DCAP16 $PINS VSS=DVSS VDD=DVDD
XFILLER_T_4_13 DCAP32 $PINS VSS=DVSS VDD=DVDD
XFILLER_T_2_13 DCAP32 $PINS VSS=DVSS VDD=DVDD
XFILLER_T_4_12 DCAP4 $PINS VSS=DVSS VDD=DVDD
XFILLER_T_2_12 DCAP4 $PINS VSS=DVSS VDD=DVDD
XFILLER_T_4_11 DCAP16 $PINS VSS=DVSS VDD=DVDD
XFILLER_T_2_11 DCAP16 $PINS VSS=DVSS VDD=DVDD
XFILLER_T_4_10 DCAP32 $PINS VSS=DVSS VDD=DVDD
XFILLER_T_2_10 DCAP32 $PINS VSS=DVSS VDD=DVDD
XFILLER_T_4_9 DCAP4 $PINS VSS=DVSS VDD=DVDD
XFILLER_T_3_7 DCAP32 $PINS VSS=DVSS VDD=DVDD
XFILLER_T_2_9 DCAP4 $PINS VSS=DVSS VDD=DVDD
XFILLER_T_4_8 DCAP16 $PINS VSS=DVSS VDD=DVDD
XFILLER_T_3_6 DCAP4 $PINS VSS=DVSS VDD=DVDD
XFILLER_T_2_8 DCAP16 $PINS VSS=DVSS VDD=DVDD
XFILLER_T_4_7 DCAP32 $PINS VSS=DVSS VDD=DVDD
XFILLER_T_3_5 DCAP16 $PINS VSS=DVSS VDD=DVDD
XFILLER_T_2_7 DCAP32 $PINS VSS=DVSS VDD=DVDD
XFILLER_T_4_6 DCAP4 $PINS VSS=DVSS VDD=DVDD
XFILLER_T_2_6 DCAP4 $PINS VSS=DVSS VDD=DVDD
XFILLER_T_1_3 DCAP4 $PINS VSS=DVSS VDD=DVDD
XFILLER_T_3_4 DCAP32 $PINS VSS=DVSS VDD=DVDD
XFILLER_T_4_5 DCAP16 $PINS VSS=DVSS VDD=DVDD
XFILLER_T_2_5 DCAP16 $PINS VSS=DVSS VDD=DVDD
XFILLER_T_4_4 DCAP32 $PINS VSS=DVSS VDD=DVDD
XFILLER_T_2_4 DCAP32 $PINS VSS=DVSS VDD=DVDD
XFILLER_T_4_3 DCAP4 $PINS VSS=DVSS VDD=DVDD
XFILLER_T_3_3 DCAP4 $PINS VSS=DVSS VDD=DVDD
XFILLER_T_2_3 DCAP4 $PINS VSS=DVSS VDD=DVDD
XFILLER_T_4_2 DCAP16 $PINS VSS=DVSS VDD=DVDD
XFILLER_T_3_2 DCAP16 $PINS VSS=DVSS VDD=DVDD
XFILLER_T_2_2 DCAP16 $PINS VSS=DVSS VDD=DVDD
XFILLER_T_4_1 DCAP32 $PINS VSS=DVSS VDD=DVDD
XFILLER_T_3_1 DCAP32 $PINS VSS=DVSS VDD=DVDD
XFILLER_T_2_1 DCAP32 $PINS VSS=DVSS VDD=DVDD
.ENDS
.GLOBAL DVDD
.GLOBAL DVSS
