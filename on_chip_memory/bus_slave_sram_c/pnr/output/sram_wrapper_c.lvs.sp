$ Spice netlist generated by v2lvs
$ v2024.3_25.13    Thu Aug 1 18:56:55 PDT 2024
.INCLUDE "/courses/ee6350/pdk2023/T-N65-CM-SP-018-K3_MOM/digital/Back_End/spice/tcbn65gplus_200a/tcbn65gplus_200a.spi"
.INCLUDE "../../../SRAM00_gen/sram00.cdl"
*.BUSDELIMITER <

.SUBCKT sram_wrapper_c clk rstn tpu_we tpu_addr<8> tpu_addr<7> tpu_addr<6>
+ tpu_addr<5> tpu_addr<4> tpu_addr<3> tpu_addr<2> tpu_addr<1> tpu_addr<0>
+ tpu_din<63> tpu_din<62> tpu_din<61> tpu_din<60> tpu_din<59> tpu_din<58>
+ tpu_din<57> tpu_din<56> tpu_din<55> tpu_din<54> tpu_din<53> tpu_din<52>
+ tpu_din<51> tpu_din<50> tpu_din<49> tpu_din<48> tpu_din<47> tpu_din<46>
+ tpu_din<45> tpu_din<44> tpu_din<43> tpu_din<42> tpu_din<41> tpu_din<40>
+ tpu_din<39> tpu_din<38> tpu_din<37> tpu_din<36> tpu_din<35> tpu_din<34>
+ tpu_din<33> tpu_din<32> tpu_din<31> tpu_din<30> tpu_din<29> tpu_din<28>
+ tpu_din<27> tpu_din<26> tpu_din<25> tpu_din<24> tpu_din<23> tpu_din<22>
+ tpu_din<21> tpu_din<20> tpu_din<19> tpu_din<18> tpu_din<17> tpu_din<16>
+ tpu_din<15> tpu_din<14> tpu_din<13> tpu_din<12> tpu_din<11> tpu_din<10>
+ tpu_din<9> tpu_din<8> tpu_din<7> tpu_din<6> tpu_din<5> tpu_din<4> tpu_din<3>
+ tpu_din<2> tpu_din<1> tpu_din<0> bus_re bus_addr<11> bus_addr<10> bus_addr<9>
+ bus_addr<8> bus_addr<7> bus_addr<6> bus_addr<5> bus_addr<4> bus_addr<3>
+ bus_addr<2> bus_addr<1> bus_addr<0> bus_dout<7> bus_dout<6> bus_dout<5>
+ bus_dout<4> bus_dout<3> bus_dout<2> bus_dout<1> bus_dout<0> DVDD DVSS
XFE_PHC235_sram_din_18 DEL015 $PINS I=sram_din<18> Z=FE_PHN235_sram_din_18
+ VSS=DVSS VDD=DVDD
XFE_PHC234_sram_din_13 DEL01 $PINS I=FE_PHN171_sram_din_13
+ Z=FE_PHN234_sram_din_13 VSS=DVSS VDD=DVDD
XFE_PHC233_sram_din_1 DEL015 $PINS I=FE_PHN233_sram_din_1
+ Z=FE_PHN186_sram_din_1 VSS=DVSS VDD=DVDD
XFE_PHC232_sram_din_8 DEL015 $PINS I=FE_PHN185_sram_din_8
+ Z=FE_PHN232_sram_din_8 VSS=DVSS VDD=DVDD
XFE_PHC231_sram_din_9 DEL0 $PINS I=FE_PHN231_sram_din_9 Z=FE_PHN177_sram_din_9
+ VSS=DVSS VDD=DVDD
XFE_PHC230_sram_din_3 DEL0 $PINS I=FE_PHN230_sram_din_3 Z=FE_PHN169_sram_din_3
+ VSS=DVSS VDD=DVDD
XFE_PHC229_sram_din_5 DEL0 $PINS I=FE_PHN229_sram_din_5 Z=FE_PHN168_sram_din_5
+ VSS=DVSS VDD=DVDD
XFE_PHC228_sram_din_4 DEL0 $PINS I=FE_PHN228_sram_din_4 Z=FE_PHN170_sram_din_4
+ VSS=DVSS VDD=DVDD
XFE_PHC227_sram_din_11 DEL0 $PINS I=FE_PHN227_sram_din_11
+ Z=FE_PHN178_sram_din_11 VSS=DVSS VDD=DVDD
XFE_PHC226_sram_din_10 DEL0 $PINS I=FE_PHN226_sram_din_10
+ Z=FE_PHN176_sram_din_10 VSS=DVSS VDD=DVDD
XFE_PHC225_sram_din_0 DEL015 $PINS I=FE_PHN225_sram_din_0
+ Z=FE_PHN184_sram_din_0 VSS=DVSS VDD=DVDD
XFE_PHC224_sram_din_12 DEL0 $PINS I=FE_PHN224_sram_din_12
+ Z=FE_PHN172_sram_din_12 VSS=DVSS VDD=DVDD
XFE_PHC223_sram_din_6 DEL0 $PINS I=FE_PHN102_sram_din_6 Z=FE_PHN223_sram_din_6
+ VSS=DVSS VDD=DVDD
XFE_PHC222_sram_din_2 DEL0 $PINS I=FE_PHN105_sram_din_2 Z=FE_PHN222_sram_din_2
+ VSS=DVSS VDD=DVDD
XFE_PHC221_sram_din_33 DEL01 $PINS I=FE_PHN221_sram_din_33 Z=sram_din<33>
+ VSS=DVSS VDD=DVDD
XFE_PHC220_sram_din_35 DEL01 $PINS I=FE_PHN220_sram_din_35 Z=sram_din<35>
+ VSS=DVSS VDD=DVDD
XFE_PHC219_sram_din_34 DEL01 $PINS I=FE_PHN219_sram_din_34 Z=sram_din<34>
+ VSS=DVSS VDD=DVDD
XFE_PHC218_sram_din_42 BUFFD2 $PINS I=FE_PHN218_sram_din_42 Z=sram_din<42>
+ VSS=DVSS VDD=DVDD
XFE_PHC217_sram_din_47 DEL01 $PINS I=FE_PHN217_sram_din_47 Z=sram_din<47>
+ VSS=DVSS VDD=DVDD
XFE_PHC216_sram_din_37 DEL01 $PINS I=FE_PHN216_sram_din_37 Z=sram_din<37>
+ VSS=DVSS VDD=DVDD
XFE_PHC215_sram_din_49 DEL01 $PINS I=FE_PHN143_sram_din_49
+ Z=FE_PHN215_sram_din_49 VSS=DVSS VDD=DVDD
XFE_PHC214_sram_din_32 DEL01 $PINS I=FE_PHN214_sram_din_32 Z=sram_din<32>
+ VSS=DVSS VDD=DVDD
XFE_PHC213_sram_din_43 DEL01 $PINS I=FE_PHN213_sram_din_43 Z=sram_din<43>
+ VSS=DVSS VDD=DVDD
XFE_PHC212_sram_din_38 DEL01 $PINS I=FE_PHN212_sram_din_38 Z=sram_din<38>
+ VSS=DVSS VDD=DVDD
XFE_PHC211_sram_din_50 DEL01 $PINS I=FE_PHN211_sram_din_50
+ Z=FE_PHN128_sram_din_50 VSS=DVSS VDD=DVDD
XFE_PHC210_sram_din_41 CKBD0 $PINS I=FE_PHN210_sram_din_41 Z=sram_din<41>
+ VSS=DVSS VDD=DVDD
XFE_PHC209_sram_din_45 DEL01 $PINS I=FE_PHN209_sram_din_45 Z=sram_din<45>
+ VSS=DVSS VDD=DVDD
XFE_PHC208_sram_din_46 DEL01 $PINS I=FE_PHN125_sram_din_46
+ Z=FE_PHN208_sram_din_46 VSS=DVSS VDD=DVDD
XFE_PHC207_sram_addr_2 DEL01 $PINS I=FE_PHN207_sram_addr_2
+ Z=FE_PHN116_sram_addr_2 VSS=DVSS VDD=DVDD
XFE_PHC206_sram_din_48 DEL01 $PINS I=FE_PHN127_sram_din_48
+ Z=FE_PHN206_sram_din_48 VSS=DVSS VDD=DVDD
XFE_PHC205_sram_addr_7 DEL01 $PINS I=FE_PHN205_sram_addr_7
+ Z=FE_PHN114_sram_addr_7 VSS=DVSS VDD=DVDD
XFE_PHC204_sram_addr_8 DEL01 $PINS I=FE_PHN204_sram_addr_8
+ Z=FE_PHN113_sram_addr_8 VSS=DVSS VDD=DVDD
XFE_PHC203_sram_din_36 DEL01 $PINS I=sram_din<36> Z=FE_PHN203_sram_din_36
+ VSS=DVSS VDD=DVDD
XFE_PHC202_sram_din_53 DEL01 $PINS I=FE_PHN202_sram_din_53 Z=sram_din<53>
+ VSS=DVSS VDD=DVDD
XFE_PHC201_sram_din_51 DEL01 $PINS I=FE_PHN201_sram_din_51 Z=sram_din<51>
+ VSS=DVSS VDD=DVDD
XFE_PHC200_sram_din_62 DEL01 $PINS I=sram_din<62> Z=FE_PHN200_sram_din_62
+ VSS=DVSS VDD=DVDD
XFE_PHC199_sram_din_54 DEL01 $PINS I=sram_din<54> Z=FE_PHN199_sram_din_54
+ VSS=DVSS VDD=DVDD
XFE_PHC198_sram_din_52 DEL01 $PINS I=sram_din<52> Z=FE_PHN198_sram_din_52
+ VSS=DVSS VDD=DVDD
XFE_PHC197_sram_din_55 DEL01 $PINS I=FE_PHN197_sram_din_55 Z=sram_din<55>
+ VSS=DVSS VDD=DVDD
XFE_PHC196_sram_din_60 DEL01 $PINS I=sram_din<60> Z=FE_PHN196_sram_din_60
+ VSS=DVSS VDD=DVDD
XFE_PHC195_sram_din_7 BUFFD2 $PINS I=FE_PHN195_sram_din_7
+ Z=FE_PHN107_sram_din_7 VSS=DVSS VDD=DVDD
XFE_PHC194_tpu_we CKBD0 $PINS I=tpu_we Z=FE_PHN194_tpu_we VSS=DVSS VDD=DVDD
XFE_PHC193_bus_addr_0 DEL01 $PINS I=bus_addr<0> Z=FE_PHN193_bus_addr_0 VSS=DVSS
+ VDD=DVDD
XFE_PHC192_bus_addr_5 DEL01 $PINS I=bus_addr<5> Z=FE_PHN192_bus_addr_5 VSS=DVSS
+ VDD=DVDD
XFE_PHC191_bus_addr_10 DEL01 $PINS I=bus_addr<10> Z=FE_PHN191_bus_addr_10
+ VSS=DVSS VDD=DVDD
XFE_PHC190_bus_addr_11 DEL01 $PINS I=bus_addr<11> Z=FE_PHN190_bus_addr_11
+ VSS=DVSS VDD=DVDD
XFE_PHC189_bus_addr_2 DEL015 $PINS I=bus_addr<2> Z=FE_PHN189_bus_addr_2
+ VSS=DVSS VDD=DVDD
XFE_PHC188_bus_addr_1 CKBD1 $PINS I=bus_addr<1> Z=FE_PHN188_bus_addr_1 VSS=DVSS
+ VDD=DVDD
XFE_PDC16_n_16 CKBD0 $PINS I=n_16 Z=FE_PDN16_n_16 VSS=DVSS VDD=DVDD
XFE_PHC187_tpu_din_18 DEL01 $PINS I=tpu_din<18> Z=FE_PHN187_tpu_din_18 VSS=DVSS
+ VDD=DVDD
XFE_PHC186_sram_din_1 BUFFD1 $PINS I=FE_PHN173_sram_din_1
+ Z=FE_PHN233_sram_din_1 VSS=DVSS VDD=DVDD
XFE_PHC185_sram_din_8 BUFFD1 $PINS I=FE_PHN175_sram_din_8
+ Z=FE_PHN185_sram_din_8 VSS=DVSS VDD=DVDD
XFE_PHC184_sram_din_0 BUFFD1 $PINS I=FE_PHN174_sram_din_0
+ Z=FE_PHN225_sram_din_0 VSS=DVSS VDD=DVDD
XFE_PHC183_sram_din_19 DEL0 $PINS I=sram_din<19> Z=FE_PHN183_sram_din_19
+ VSS=DVSS VDD=DVDD
XFE_PHC182_sram_din_20 DEL0 $PINS I=sram_din<20> Z=FE_PHN182_sram_din_20
+ VSS=DVSS VDD=DVDD
XFE_PHC181_sram_din_21 DEL0 $PINS I=sram_din<21> Z=FE_PHN181_sram_din_21
+ VSS=DVSS VDD=DVDD
XFE_PHC180_bus_addr_2 BUFFD1 $PINS I=FE_PHN189_bus_addr_2
+ Z=FE_PHN180_bus_addr_2 VSS=DVSS VDD=DVDD
XFE_PHC179_tpu_we DEL1 $PINS I=FE_PHN194_tpu_we Z=FE_PHN179_tpu_we VSS=DVSS
+ VDD=DVDD
XFE_PHC178_sram_din_11 CKBD0 $PINS I=FE_PHN100_sram_din_11
+ Z=FE_PHN227_sram_din_11 VSS=DVSS VDD=DVDD
XFE_PHC177_sram_din_9 CKBD0 $PINS I=FE_PHN97_sram_din_9 Z=FE_PHN231_sram_din_9
+ VSS=DVSS VDD=DVDD
XFE_PHC176_sram_din_10 CKBD0 $PINS I=FE_PHN95_sram_din_10
+ Z=FE_PHN226_sram_din_10 VSS=DVSS VDD=DVDD
XFE_PHC175_sram_din_8 DEL005 $PINS I=FE_PHN98_sram_din_8 Z=FE_PHN175_sram_din_8
+ VSS=DVSS VDD=DVDD
XFE_PHC174_sram_din_0 CKBD0 $PINS I=FE_PHN101_sram_din_0 Z=FE_PHN174_sram_din_0
+ VSS=DVSS VDD=DVDD
XFE_PHC173_sram_din_1 CKBD0 $PINS I=FE_PHN99_sram_din_1 Z=FE_PHN173_sram_din_1
+ VSS=DVSS VDD=DVDD
XFE_PHC172_sram_din_12 CKBD0 $PINS I=FE_PHN94_sram_din_12
+ Z=FE_PHN224_sram_din_12 VSS=DVSS VDD=DVDD
XFE_PHC171_sram_din_13 DEL01 $PINS I=FE_PHN96_sram_din_13
+ Z=FE_PHN171_sram_din_13 VSS=DVSS VDD=DVDD
XFE_PHC170_sram_din_4 CKBD0 $PINS I=FE_PHN103_sram_din_4 Z=FE_PHN228_sram_din_4
+ VSS=DVSS VDD=DVDD
XFE_PHC169_sram_din_3 CKBD0 $PINS I=FE_PHN104_sram_din_3 Z=FE_PHN230_sram_din_3
+ VSS=DVSS VDD=DVDD
XFE_PHC168_sram_din_5 CKBD0 $PINS I=FE_PHN106_sram_din_5 Z=FE_PHN229_sram_din_5
+ VSS=DVSS VDD=DVDD
XFE_PHC167_sram_din_33 DEL015 $PINS I=FE_PHN93_sram_din_33
+ Z=FE_PHN167_sram_din_33 VSS=DVSS VDD=DVDD
XFE_PHC166_sram_din_32 DEL015 $PINS I=FE_PHN92_sram_din_32
+ Z=FE_PHN166_sram_din_32 VSS=DVSS VDD=DVDD
XFE_PHC165_sram_din_35 DEL015 $PINS I=FE_PHN91_sram_din_35
+ Z=FE_PHN165_sram_din_35 VSS=DVSS VDD=DVDD
XFE_PHC164_sram_din_34 DEL015 $PINS I=FE_PHN90_sram_din_34
+ Z=FE_PHN164_sram_din_34 VSS=DVSS VDD=DVDD
XFE_PHC163_sram_din_37 DEL015 $PINS I=FE_PHN89_sram_din_37
+ Z=FE_PHN163_sram_din_37 VSS=DVSS VDD=DVDD
XFE_PHC162_sram_din_38 DEL015 $PINS I=FE_PHN86_sram_din_38
+ Z=FE_PHN162_sram_din_38 VSS=DVSS VDD=DVDD
XFE_PHC161_sram_din_36 DEL015 $PINS I=FE_PHN81_sram_din_36
+ Z=FE_PHN161_sram_din_36 VSS=DVSS VDD=DVDD
XFE_PHC160_sram_din_31 DEL1 $PINS I=sram_din<31> Z=FE_PHN160_sram_din_31
+ VSS=DVSS VDD=DVDD
XFE_PHC159_sram_din_16 DEL1 $PINS I=sram_din<16> Z=FE_PHN159_sram_din_16
+ VSS=DVSS VDD=DVDD
XFE_PHC158_sram_din_28 DEL1 $PINS I=sram_din<28> Z=FE_PHN158_sram_din_28
+ VSS=DVSS VDD=DVDD
XFE_PHC157_sram_din_22 DEL1 $PINS I=sram_din<22> Z=FE_PHN157_sram_din_22
+ VSS=DVSS VDD=DVDD
XFE_PHC156_sram_din_23 DEL1 $PINS I=sram_din<23> Z=FE_PHN156_sram_din_23
+ VSS=DVSS VDD=DVDD
XFE_PHC155_sram_din_24 DEL1 $PINS I=sram_din<24> Z=FE_PHN155_sram_din_24
+ VSS=DVSS VDD=DVDD
XFE_PHC154_sram_din_25 DEL1 $PINS I=sram_din<25> Z=FE_PHN154_sram_din_25
+ VSS=DVSS VDD=DVDD
XFE_PHC153_sram_din_26 DEL1 $PINS I=sram_din<26> Z=FE_PHN153_sram_din_26
+ VSS=DVSS VDD=DVDD
XFE_PHC152_sram_din_29 DEL1 $PINS I=sram_din<29> Z=FE_PHN152_sram_din_29
+ VSS=DVSS VDD=DVDD
XFE_PHC151_sram_din_27 DEL1 $PINS I=sram_din<27> Z=FE_PHN151_sram_din_27
+ VSS=DVSS VDD=DVDD
XFE_PHC150_sram_din_14 DEL1 $PINS I=sram_din<14> Z=FE_PHN150_sram_din_14
+ VSS=DVSS VDD=DVDD
XFE_PHC149_sram_din_15 DEL1 $PINS I=sram_din<15> Z=FE_PHN149_sram_din_15
+ VSS=DVSS VDD=DVDD
XFE_PHC148_sram_din_44 DEL0 $PINS I=sram_din<44> Z=FE_PHN148_sram_din_44
+ VSS=DVSS VDD=DVDD
XFE_PHC147_sram_addr_4 DEL0 $PINS I=sram_addr<4> Z=FE_PHN147_sram_addr_4
+ VSS=DVSS VDD=DVDD
XFE_PHC146_sram_din_41 DEL015 $PINS I=sram_din<41> Z=FE_PHN146_sram_din_41
+ VSS=DVSS VDD=DVDD
XFE_PHC145_bus_addr_1 DEL015 $PINS I=FE_PHN22_bus_addr_1 Z=FE_PHN145_bus_addr_1
+ VSS=DVSS VDD=DVDD
XFE_PHC144_sram_din_39 DEL0 $PINS I=sram_din<39> Z=FE_PHN144_sram_din_39
+ VSS=DVSS VDD=DVDD
XFE_PHC143_sram_din_49 DEL015 $PINS I=sram_din<49> Z=FE_PHN143_sram_din_49
+ VSS=DVSS VDD=DVDD
XFE_PHC142_bus_addr_0 DEL015 $PINS I=FE_PHN24_bus_addr_0 Z=FE_PHN142_bus_addr_0
+ VSS=DVSS VDD=DVDD
XFE_PHC141_sram_din_40 DEL0 $PINS I=sram_din<40> Z=FE_PHN141_sram_din_40
+ VSS=DVSS VDD=DVDD
XFE_PHC140_sram_din_42 DEL015 $PINS I=sram_din<42> Z=FE_PHN140_sram_din_42
+ VSS=DVSS VDD=DVDD
XFE_PHC139_sram_din_47 DEL015 $PINS I=sram_din<47> Z=FE_PHN139_sram_din_47
+ VSS=DVSS VDD=DVDD
XFE_PHC138_sram_din_43 DEL015 $PINS I=sram_din<43> Z=FE_PHN138_sram_din_43
+ VSS=DVSS VDD=DVDD
XFE_PHC137_sram_addr_0 DEL0 $PINS I=sram_addr<0> Z=FE_PHN137_sram_addr_0
+ VSS=DVSS VDD=DVDD
XFE_PHC136_sram_din_58 DEL0 $PINS I=sram_din<58> Z=FE_PHN136_sram_din_58
+ VSS=DVSS VDD=DVDD
XFE_PHC135_sram_din_56 DEL0 $PINS I=sram_din<56> Z=FE_PHN135_sram_din_56
+ VSS=DVSS VDD=DVDD
XFE_PHC134_sram_din_59 DEL0 $PINS I=sram_din<59> Z=FE_PHN134_sram_din_59
+ VSS=DVSS VDD=DVDD
XFE_PHC133_sram_din_57 DEL0 $PINS I=sram_din<57> Z=FE_PHN133_sram_din_57
+ VSS=DVSS VDD=DVDD
XFE_PHC132_sram_din_61 DEL0 $PINS I=sram_din<61> Z=FE_PHN132_sram_din_61
+ VSS=DVSS VDD=DVDD
XFE_PHC131_sram_din_63 DEL0 $PINS I=sram_din<63> Z=FE_PHN131_sram_din_63
+ VSS=DVSS VDD=DVDD
XFE_PHC130_sram_addr_1 DEL0 $PINS I=sram_addr<1> Z=FE_PHN130_sram_addr_1
+ VSS=DVSS VDD=DVDD
XFE_PHC129_sram_din_45 DEL015 $PINS I=sram_din<45> Z=FE_PHN129_sram_din_45
+ VSS=DVSS VDD=DVDD
XFE_PHC128_sram_din_50 DEL015 $PINS I=sram_din<50> Z=FE_PHN211_sram_din_50
+ VSS=DVSS VDD=DVDD
XFE_PHC127_sram_din_48 DEL015 $PINS I=sram_din<48> Z=FE_PHN127_sram_din_48
+ VSS=DVSS VDD=DVDD
XFE_PHC126_sram_din_51 DEL015 $PINS I=sram_din<51> Z=FE_PHN126_sram_din_51
+ VSS=DVSS VDD=DVDD
XFE_PHC125_sram_din_46 DEL015 $PINS I=sram_din<46> Z=FE_PHN125_sram_din_46
+ VSS=DVSS VDD=DVDD
XFE_PHC124_sram_din_52 DEL015 $PINS I=FE_PHN198_sram_din_52
+ Z=FE_PHN124_sram_din_52 VSS=DVSS VDD=DVDD
XFE_PHC123_sram_addr_6 DEL0 $PINS I=sram_addr<6> Z=FE_PHN123_sram_addr_6
+ VSS=DVSS VDD=DVDD
XFE_PHC122_sram_din_62 DEL015 $PINS I=FE_PHN200_sram_din_62
+ Z=FE_PHN122_sram_din_62 VSS=DVSS VDD=DVDD
XFE_PHC121_sram_din_53 DEL015 $PINS I=sram_din<53> Z=FE_PHN121_sram_din_53
+ VSS=DVSS VDD=DVDD
XFE_PHC120_sram_din_60 DEL015 $PINS I=FE_PHN196_sram_din_60
+ Z=FE_PHN120_sram_din_60 VSS=DVSS VDD=DVDD
XFE_PHC119_sram_din_54 DEL015 $PINS I=FE_PHN199_sram_din_54
+ Z=FE_PHN119_sram_din_54 VSS=DVSS VDD=DVDD
XFE_PHC118_sram_addr_5 DEL0 $PINS I=sram_addr<5> Z=FE_PHN118_sram_addr_5
+ VSS=DVSS VDD=DVDD
XFE_PHC117_sram_din_55 DEL015 $PINS I=sram_din<55> Z=FE_PHN117_sram_din_55
+ VSS=DVSS VDD=DVDD
XFE_PHC116_sram_addr_2 DEL015 $PINS I=sram_addr<2> Z=FE_PHN207_sram_addr_2
+ VSS=DVSS VDD=DVDD
XFE_PHC115_sram_addr_3 DEL0 $PINS I=sram_addr<3> Z=FE_PHN115_sram_addr_3
+ VSS=DVSS VDD=DVDD
XFE_PHC114_sram_addr_7 DEL015 $PINS I=sram_addr<7> Z=FE_PHN205_sram_addr_7
+ VSS=DVSS VDD=DVDD
XFE_PHC113_sram_addr_8 DEL015 $PINS I=sram_addr<8> Z=FE_PHN204_sram_addr_8
+ VSS=DVSS VDD=DVDD
XFE_PHC112_sram_cen DEL0 $PINS I=sram_cen Z=FE_PHN112_sram_cen VSS=DVSS
+ VDD=DVDD
XFE_PHC111_sram_din_30 DEL1 $PINS I=sram_din<30> Z=FE_PHN111_sram_din_30
+ VSS=DVSS VDD=DVDD
XFE_PHC110_tpu_we BUFFD1 $PINS I=tpu_we Z=FE_PHN110_tpu_we VSS=DVSS VDD=DVDD
XFE_PHC109_bus_addr_2 CKBD0 $PINS I=FE_PHN180_bus_addr_2 Z=FE_PHN109_bus_addr_2
+ VSS=DVSS VDD=DVDD
XFE_PHC108_rstn DEL1 $PINS I=rstn Z=FE_PHN108_rstn VSS=DVSS VDD=DVDD
XFE_PHC107_sram_din_7 BUFFD2 $PINS I=sram_din<7> Z=FE_PHN195_sram_din_7
+ VSS=DVSS VDD=DVDD
XFE_PHC106_sram_din_5 DEL1 $PINS I=sram_din<5> Z=FE_PHN106_sram_din_5 VSS=DVSS
+ VDD=DVDD
XFE_PHC105_sram_din_2 DEL1 $PINS I=sram_din<2> Z=FE_PHN105_sram_din_2 VSS=DVSS
+ VDD=DVDD
XFE_PHC104_sram_din_3 DEL1 $PINS I=sram_din<3> Z=FE_PHN104_sram_din_3 VSS=DVSS
+ VDD=DVDD
XFE_PHC103_sram_din_4 DEL1 $PINS I=sram_din<4> Z=FE_PHN103_sram_din_4 VSS=DVSS
+ VDD=DVDD
XFE_PHC102_sram_din_6 DEL1 $PINS I=sram_din<6> Z=FE_PHN102_sram_din_6 VSS=DVSS
+ VDD=DVDD
XFE_PHC101_sram_din_0 DEL1 $PINS I=sram_din<0> Z=FE_PHN101_sram_din_0 VSS=DVSS
+ VDD=DVDD
XFE_PHC100_sram_din_11 DEL1 $PINS I=sram_din<11> Z=FE_PHN100_sram_din_11
+ VSS=DVSS VDD=DVDD
XFE_PHC99_sram_din_1 DEL1 $PINS I=sram_din<1> Z=FE_PHN99_sram_din_1 VSS=DVSS
+ VDD=DVDD
XFE_PHC98_sram_din_8 DEL1 $PINS I=sram_din<8> Z=FE_PHN98_sram_din_8 VSS=DVSS
+ VDD=DVDD
XFE_PHC97_sram_din_9 DEL1 $PINS I=sram_din<9> Z=FE_PHN97_sram_din_9 VSS=DVSS
+ VDD=DVDD
XFE_PHC96_sram_din_13 DEL1 $PINS I=sram_din<13> Z=FE_PHN96_sram_din_13 VSS=DVSS
+ VDD=DVDD
XFE_PHC95_sram_din_10 DEL1 $PINS I=sram_din<10> Z=FE_PHN95_sram_din_10 VSS=DVSS
+ VDD=DVDD
XFE_PHC94_sram_din_12 DEL1 $PINS I=sram_din<12> Z=FE_PHN94_sram_din_12 VSS=DVSS
+ VDD=DVDD
XFE_PHC93_sram_din_33 DEL1 $PINS I=sram_din<33> Z=FE_PHN93_sram_din_33 VSS=DVSS
+ VDD=DVDD
XFE_PHC92_sram_din_32 DEL1 $PINS I=sram_din<32> Z=FE_PHN92_sram_din_32 VSS=DVSS
+ VDD=DVDD
XFE_PHC91_sram_din_35 DEL1 $PINS I=sram_din<35> Z=FE_PHN91_sram_din_35 VSS=DVSS
+ VDD=DVDD
XFE_PHC90_sram_din_34 DEL1 $PINS I=sram_din<34> Z=FE_PHN90_sram_din_34 VSS=DVSS
+ VDD=DVDD
XFE_PHC89_sram_din_37 DEL1 $PINS I=sram_din<37> Z=FE_PHN89_sram_din_37 VSS=DVSS
+ VDD=DVDD
XFE_PHC88_sram_din_39 DEL1 $PINS I=FE_PHN144_sram_din_39 Z=FE_PHN88_sram_din_39
+ VSS=DVSS VDD=DVDD
XFE_PHC87_sram_din_41 DEL1 $PINS I=FE_PHN146_sram_din_41 Z=FE_PHN87_sram_din_41
+ VSS=DVSS VDD=DVDD
XFE_PHC86_sram_din_38 DEL1 $PINS I=sram_din<38> Z=FE_PHN86_sram_din_38 VSS=DVSS
+ VDD=DVDD
XFE_PHC85_sram_din_40 DEL1 $PINS I=FE_PHN141_sram_din_40 Z=FE_PHN85_sram_din_40
+ VSS=DVSS VDD=DVDD
XFE_PHC84_sram_din_42 DEL1 $PINS I=FE_PHN140_sram_din_42 Z=FE_PHN84_sram_din_42
+ VSS=DVSS VDD=DVDD
XFE_PHC83_sram_din_44 DEL1 $PINS I=FE_PHN148_sram_din_44 Z=FE_PHN83_sram_din_44
+ VSS=DVSS VDD=DVDD
XFE_PHC82_sram_din_43 DEL1 $PINS I=FE_PHN138_sram_din_43 Z=FE_PHN82_sram_din_43
+ VSS=DVSS VDD=DVDD
XFE_PHC81_sram_din_36 DEL1 $PINS I=FE_PHN203_sram_din_36 Z=FE_PHN81_sram_din_36
+ VSS=DVSS VDD=DVDD
XFE_PHC80_sram_addr_6 DEL1 $PINS I=FE_PHN123_sram_addr_6 Z=FE_PHN80_sram_addr_6
+ VSS=DVSS VDD=DVDD
XFE_PHC79_sram_addr_4 DEL1 $PINS I=FE_PHN147_sram_addr_4 Z=FE_PHN79_sram_addr_4
+ VSS=DVSS VDD=DVDD
XFE_PHC78_sram_addr_0 DEL1 $PINS I=FE_PHN137_sram_addr_0 Z=FE_PHN78_sram_addr_0
+ VSS=DVSS VDD=DVDD
XFE_PHC77_sram_addr_2 DEL1 $PINS I=FE_PHN116_sram_addr_2 Z=FE_PHN77_sram_addr_2
+ VSS=DVSS VDD=DVDD
XFE_PHC76_sram_addr_5 DEL1 $PINS I=FE_PHN118_sram_addr_5 Z=FE_PHN76_sram_addr_5
+ VSS=DVSS VDD=DVDD
XFE_PHC75_sram_addr_1 DEL1 $PINS I=FE_PHN130_sram_addr_1 Z=FE_PHN75_sram_addr_1
+ VSS=DVSS VDD=DVDD
XFE_PHC74_sram_addr_3 DEL1 $PINS I=FE_PHN115_sram_addr_3 Z=FE_PHN74_sram_addr_3
+ VSS=DVSS VDD=DVDD
XFE_PHC73_sram_addr_7 DEL1 $PINS I=FE_PHN114_sram_addr_7 Z=FE_PHN73_sram_addr_7
+ VSS=DVSS VDD=DVDD
XFE_PHC72_sram_addr_8 DEL1 $PINS I=FE_PHN113_sram_addr_8 Z=FE_PHN72_sram_addr_8
+ VSS=DVSS VDD=DVDD
XFE_PHC71_sram_din_45 DEL1 $PINS I=FE_PHN129_sram_din_45 Z=FE_PHN71_sram_din_45
+ VSS=DVSS VDD=DVDD
XFE_PHC70_sram_din_47 DEL1 $PINS I=FE_PHN139_sram_din_47 Z=FE_PHN70_sram_din_47
+ VSS=DVSS VDD=DVDD
XFE_PHC69_sram_din_46 DEL1 $PINS I=FE_PHN208_sram_din_46 Z=FE_PHN69_sram_din_46
+ VSS=DVSS VDD=DVDD
XFE_PHC68_sram_din_49 DEL1 $PINS I=FE_PHN215_sram_din_49 Z=FE_PHN68_sram_din_49
+ VSS=DVSS VDD=DVDD
XFE_PHC67_sram_din_48 DEL1 $PINS I=FE_PHN206_sram_din_48 Z=FE_PHN67_sram_din_48
+ VSS=DVSS VDD=DVDD
XFE_PHC66_sram_din_50 DEL1 $PINS I=FE_PHN128_sram_din_50 Z=FE_PHN66_sram_din_50
+ VSS=DVSS VDD=DVDD
XFE_PHC65_sram_din_53 DEL1 $PINS I=FE_PHN121_sram_din_53 Z=FE_PHN65_sram_din_53
+ VSS=DVSS VDD=DVDD
XFE_PHC64_sram_din_52 DEL1 $PINS I=FE_PHN124_sram_din_52 Z=FE_PHN64_sram_din_52
+ VSS=DVSS VDD=DVDD
XFE_PHC63_sram_din_51 DEL1 $PINS I=FE_PHN126_sram_din_51 Z=FE_PHN63_sram_din_51
+ VSS=DVSS VDD=DVDD
XFE_PHC62_sram_din_54 DEL1 $PINS I=FE_PHN119_sram_din_54 Z=FE_PHN62_sram_din_54
+ VSS=DVSS VDD=DVDD
XFE_PHC61_sram_din_62 DEL1 $PINS I=FE_PHN122_sram_din_62 Z=FE_PHN61_sram_din_62
+ VSS=DVSS VDD=DVDD
XFE_PHC60_sram_din_60 DEL1 $PINS I=FE_PHN120_sram_din_60 Z=FE_PHN60_sram_din_60
+ VSS=DVSS VDD=DVDD
XFE_PHC59_sram_din_56 DEL1 $PINS I=FE_PHN135_sram_din_56 Z=FE_PHN59_sram_din_56
+ VSS=DVSS VDD=DVDD
XFE_PHC58_sram_din_61 DEL1 $PINS I=FE_PHN132_sram_din_61 Z=FE_PHN58_sram_din_61
+ VSS=DVSS VDD=DVDD
XFE_PHC57_sram_din_63 DEL1 $PINS I=FE_PHN131_sram_din_63 Z=FE_PHN57_sram_din_63
+ VSS=DVSS VDD=DVDD
XFE_PHC56_sram_din_59 DEL1 $PINS I=FE_PHN134_sram_din_59 Z=FE_PHN56_sram_din_59
+ VSS=DVSS VDD=DVDD
XFE_PHC55_sram_din_57 DEL1 $PINS I=FE_PHN133_sram_din_57 Z=FE_PHN55_sram_din_57
+ VSS=DVSS VDD=DVDD
XFE_PHC54_FE_OFN10_bus_dout_5 DEL1 $PINS I=FE_OFN10_bus_dout_5
+ Z=FE_PHN54_FE_OFN10_bus_dout_5 VSS=DVSS VDD=DVDD
XFE_PHC53_FE_OFN11_bus_dout_4 DEL1 $PINS I=FE_OFN11_bus_dout_4
+ Z=FE_PHN53_FE_OFN11_bus_dout_4 VSS=DVSS VDD=DVDD
XFE_PHC52_sram_din_55 DEL1 $PINS I=FE_PHN117_sram_din_55 Z=FE_PHN52_sram_din_55
+ VSS=DVSS VDD=DVDD
XFE_PHC51_rstn DEL1 $PINS I=rstn Z=FE_PHN51_rstn VSS=DVSS VDD=DVDD
XFE_PHC50_FE_OFN13_bus_dout_2 DEL1 $PINS I=FE_OFN13_bus_dout_2
+ Z=FE_PHN50_FE_OFN13_bus_dout_2 VSS=DVSS VDD=DVDD
XFE_PHC49_FE_OFN12_bus_dout_3 DEL1 $PINS I=FE_OFN12_bus_dout_3
+ Z=FE_PHN49_FE_OFN12_bus_dout_3 VSS=DVSS VDD=DVDD
XFE_PHC48_FE_OFN15_bus_dout_0 DEL1 $PINS I=FE_OFN15_bus_dout_0
+ Z=FE_PHN48_FE_OFN15_bus_dout_0 VSS=DVSS VDD=DVDD
XFE_PHC47_FE_OFN9_bus_dout_6 DEL1 $PINS I=FE_OFN9_bus_dout_6
+ Z=FE_PHN47_FE_OFN9_bus_dout_6 VSS=DVSS VDD=DVDD
XFE_PHC46_FE_OFN14_bus_dout_1 DEL1 $PINS I=FE_OFN14_bus_dout_1
+ Z=FE_PHN46_FE_OFN14_bus_dout_1 VSS=DVSS VDD=DVDD
XFE_PHC45_n_38 DEL0 $PINS I=n_38 Z=FE_PHN45_n_38 VSS=DVSS VDD=DVDD
XFE_PHC44_n_14 DEL0 $PINS I=n_14 Z=FE_PHN44_n_14 VSS=DVSS VDD=DVDD
XFE_PHC43_FE_OFN8_bus_dout_7 DEL1 $PINS I=FE_OFN8_bus_dout_7
+ Z=FE_PHN43_FE_OFN8_bus_dout_7 VSS=DVSS VDD=DVDD
XFE_PHC42_sram_din_58 DEL1 $PINS I=FE_PHN136_sram_din_58 Z=FE_PHN42_sram_din_58
+ VSS=DVSS VDD=DVDD
XFE_PHC41_sram_cen DEL1 $PINS I=FE_PHN112_sram_cen Z=FE_PHN41_sram_cen VSS=DVSS
+ VDD=DVDD
XFE_PHC40_tpu_we CKBD2 $PINS I=FE_PHN179_tpu_we Z=FE_PHN40_tpu_we VSS=DVSS
+ VDD=DVDD
XFE_PHC39_tpu_din_17 DEL2 $PINS I=tpu_din<17> Z=FE_PHN39_tpu_din_17 VSS=DVSS
+ VDD=DVDD
XFE_PHC38_bus_byte_sel_d1_2 DEL1 $PINS I=bus_byte_sel_d1<2>
+ Z=FE_PHN38_bus_byte_sel_d1_2 VSS=DVSS VDD=DVDD
XFE_PHC37_bus_byte_sel_d1_1 DEL1 $PINS I=bus_byte_sel_d1<1>
+ Z=FE_PHN37_bus_byte_sel_d1_1 VSS=DVSS VDD=DVDD
XFE_PHC36_bus_byte_sel_d1_0 DEL1 $PINS I=bus_byte_sel_d1<0>
+ Z=FE_PHN36_bus_byte_sel_d1_0 VSS=DVSS VDD=DVDD
XFE_PHC35_tpu_din_18 DEL1 $PINS I=FE_PHN187_tpu_din_18 Z=FE_PHN35_tpu_din_18
+ VSS=DVSS VDD=DVDD
XFE_PHC34_tpu_din_31 DEL1 $PINS I=tpu_din<31> Z=FE_PHN34_tpu_din_31 VSS=DVSS
+ VDD=DVDD
XFE_PHC33_tpu_din_20 DEL1 $PINS I=tpu_din<20> Z=FE_PHN33_tpu_din_20 VSS=DVSS
+ VDD=DVDD
XFE_PHC32_tpu_din_16 DEL1 $PINS I=tpu_din<16> Z=FE_PHN32_tpu_din_16 VSS=DVSS
+ VDD=DVDD
XFE_PHC31_tpu_din_19 DEL1 $PINS I=tpu_din<19> Z=FE_PHN31_tpu_din_19 VSS=DVSS
+ VDD=DVDD
XFE_PHC30_tpu_din_21 DEL1 $PINS I=tpu_din<21> Z=FE_PHN30_tpu_din_21 VSS=DVSS
+ VDD=DVDD
XFE_PHC29_tpu_din_28 DEL1 $PINS I=tpu_din<28> Z=FE_PHN29_tpu_din_28 VSS=DVSS
+ VDD=DVDD
XFE_PHC28_tpu_din_22 DEL1 $PINS I=tpu_din<22> Z=FE_PHN28_tpu_din_22 VSS=DVSS
+ VDD=DVDD
XFE_PHC27_tpu_din_23 DEL1 $PINS I=tpu_din<23> Z=FE_PHN27_tpu_din_23 VSS=DVSS
+ VDD=DVDD
XFE_PHC26_tpu_din_24 DEL1 $PINS I=tpu_din<24> Z=FE_PHN26_tpu_din_24 VSS=DVSS
+ VDD=DVDD
XFE_PHC25_tpu_din_25 DEL1 $PINS I=tpu_din<25> Z=FE_PHN25_tpu_din_25 VSS=DVSS
+ VDD=DVDD
XFE_PHC24_bus_addr_0 DEL1 $PINS I=FE_PHN193_bus_addr_0 Z=FE_PHN24_bus_addr_0
+ VSS=DVSS VDD=DVDD
XFE_PHC23_bus_addr_2 DEL1 $PINS I=FE_PHN109_bus_addr_2 Z=FE_PHN23_bus_addr_2
+ VSS=DVSS VDD=DVDD
XFE_PHC22_bus_addr_1 DEL1 $PINS I=FE_PHN188_bus_addr_1 Z=FE_PHN22_bus_addr_1
+ VSS=DVSS VDD=DVDD
XFE_PHC21_tpu_din_26 DEL1 $PINS I=tpu_din<26> Z=FE_PHN21_tpu_din_26 VSS=DVSS
+ VDD=DVDD
XFE_PHC20_tpu_din_14 DEL1 $PINS I=tpu_din<14> Z=FE_PHN20_tpu_din_14 VSS=DVSS
+ VDD=DVDD
XFE_PHC19_tpu_din_29 DEL1 $PINS I=tpu_din<29> Z=FE_PHN19_tpu_din_29 VSS=DVSS
+ VDD=DVDD
XFE_PHC18_tpu_din_15 DEL1 $PINS I=tpu_din<15> Z=FE_PHN18_tpu_din_15 VSS=DVSS
+ VDD=DVDD
XFE_PHC17_tpu_din_27 DEL1 $PINS I=tpu_din<27> Z=FE_PHN17_tpu_din_27 VSS=DVSS
+ VDD=DVDD
XFE_PHC16_tpu_din_30 DEL1 $PINS I=tpu_din<30> Z=FE_PHN16_tpu_din_30 VSS=DVSS
+ VDD=DVDD
XCTS_ccl_a_inv_00001 CKND6 $PINS I=CTS_2 ZN=CTS_1 VSS=DVSS VDD=DVDD
XCTS_cmf_inv_00047 CKND1 $PINS I=clk ZN=CTS_2 VSS=DVSS VDD=DVDD
XLTIELO TIEL $PINS ZN=LTIELO_NET VSS=DVSS VDD=DVDD
XLTIEHI TIEH $PINS Z=LTIEHI_NET VSS=DVSS VDD=DVDD
XFE_OFC15_bus_dout_0 BUFFD16 $PINS I=FE_PHN48_FE_OFN15_bus_dout_0 Z=bus_dout<0>
+ VSS=DVSS VDD=DVDD
XFE_OFC14_bus_dout_1 BUFFD16 $PINS I=FE_PHN46_FE_OFN14_bus_dout_1 Z=bus_dout<1>
+ VSS=DVSS VDD=DVDD
XFE_OFC13_bus_dout_2 BUFFD12 $PINS I=FE_PHN50_FE_OFN13_bus_dout_2 Z=bus_dout<2>
+ VSS=DVSS VDD=DVDD
XFE_OFC12_bus_dout_3 BUFFD16 $PINS I=FE_PHN49_FE_OFN12_bus_dout_3 Z=bus_dout<3>
+ VSS=DVSS VDD=DVDD
XFE_OFC11_bus_dout_4 BUFFD12 $PINS I=FE_PHN53_FE_OFN11_bus_dout_4 Z=bus_dout<4>
+ VSS=DVSS VDD=DVDD
XFE_OFC10_bus_dout_5 BUFFD12 $PINS I=FE_PHN54_FE_OFN10_bus_dout_5 Z=bus_dout<5>
+ VSS=DVSS VDD=DVDD
XFE_OFC9_bus_dout_6 BUFFD12 $PINS I=FE_PHN47_FE_OFN9_bus_dout_6 Z=bus_dout<6>
+ VSS=DVSS VDD=DVDD
XFE_OFC8_bus_dout_7 BUFFD16 $PINS I=FE_PHN43_FE_OFN8_bus_dout_7 Z=bus_dout<7>
+ VSS=DVSS VDD=DVDD
XFE_OFC7_n_43 CKBD1 $PINS I=n_43 Z=FE_OFN7_n_43 VSS=DVSS VDD=DVDD
XFE_OFC6_n_36 CKBD1 $PINS I=n_36 Z=FE_OFN6_n_36 VSS=DVSS VDD=DVDD
XFE_OFC5_n_32 CKBD0 $PINS I=n_32 Z=FE_OFN5_n_32 VSS=DVSS VDD=DVDD
XFE_OFC4_n_26 CKBD1 $PINS I=n_26 Z=FE_OFN4_n_26 VSS=DVSS VDD=DVDD
XFE_OFC3_n_25 CKBD1 $PINS I=n_25 Z=FE_OFN3_n_25 VSS=DVSS VDD=DVDD
XFE_OFC2_n_22 CKBD1 $PINS I=n_22 Z=FE_OFN2_n_22 VSS=DVSS VDD=DVDD
XFE_OFC1_n_21 CKBD1 $PINS I=n_21 Z=FE_OFN1_n_21 VSS=DVSS VDD=DVDD
XFE_OFC0_n_15 BUFFD2 $PINS I=n_15 Z=FE_OFN0_n_15 VSS=DVSS VDD=DVDD
Xu_sram sram00 $PINS Q<63>=sram_q<63> Q<62>=sram_q<62> Q<61>=sram_q<61>
+ Q<60>=sram_q<60> Q<59>=sram_q<59> Q<58>=sram_q<58> Q<57>=sram_q<57>
+ Q<56>=sram_q<56> Q<55>=sram_q<55> Q<54>=sram_q<54> Q<53>=sram_q<53>
+ Q<52>=sram_q<52> Q<51>=sram_q<51> Q<50>=sram_q<50> Q<49>=sram_q<49>
+ Q<48>=sram_q<48> Q<47>=sram_q<47> Q<46>=sram_q<46> Q<45>=sram_q<45>
+ Q<44>=sram_q<44> Q<43>=sram_q<43> Q<42>=sram_q<42> Q<41>=sram_q<41>
+ Q<40>=sram_q<40> Q<39>=sram_q<39> Q<38>=sram_q<38> Q<37>=sram_q<37>
+ Q<36>=sram_q<36> Q<35>=sram_q<35> Q<34>=sram_q<34> Q<33>=sram_q<33>
+ Q<32>=sram_q<32> Q<31>=sram_q<31> Q<30>=sram_q<30> Q<29>=sram_q<29>
+ Q<28>=sram_q<28> Q<27>=sram_q<27> Q<26>=sram_q<26> Q<25>=sram_q<25>
+ Q<24>=sram_q<24> Q<23>=sram_q<23> Q<22>=sram_q<22> Q<21>=sram_q<21>
+ Q<20>=sram_q<20> Q<19>=sram_q<19> Q<18>=sram_q<18> Q<17>=sram_q<17>
+ Q<16>=sram_q<16> Q<15>=sram_q<15> Q<14>=sram_q<14> Q<13>=sram_q<13>
+ Q<12>=sram_q<12> Q<11>=sram_q<11> Q<10>=sram_q<10> Q<9>=sram_q<9>
+ Q<8>=sram_q<8> Q<7>=n_60 Q<6>=n_61 Q<5>=n_62 Q<4>=n_63 Q<3>=n_64 Q<2>=n_65
+ Q<1>=n_66 Q<0>=n_67 CLK=CTS_1 CEN=FE_PHN41_sram_cen WEN=n_0
+ A<8>=FE_PHN72_sram_addr_8 A<7>=FE_PHN73_sram_addr_7 A<6>=FE_PHN80_sram_addr_6
+ A<5>=FE_PHN76_sram_addr_5 A<4>=FE_PHN79_sram_addr_4 A<3>=FE_PHN74_sram_addr_3
+ A<2>=FE_PHN77_sram_addr_2 A<1>=FE_PHN75_sram_addr_1 A<0>=FE_PHN78_sram_addr_0
+ D<63>=FE_PHN57_sram_din_63 D<62>=FE_PHN61_sram_din_62
+ D<61>=FE_PHN58_sram_din_61 D<60>=FE_PHN60_sram_din_60
+ D<59>=FE_PHN56_sram_din_59 D<58>=FE_PHN42_sram_din_58
+ D<57>=FE_PHN55_sram_din_57 D<56>=FE_PHN59_sram_din_56
+ D<55>=FE_PHN52_sram_din_55 D<54>=FE_PHN62_sram_din_54
+ D<53>=FE_PHN65_sram_din_53 D<52>=FE_PHN64_sram_din_52
+ D<51>=FE_PHN63_sram_din_51 D<50>=FE_PHN66_sram_din_50
+ D<49>=FE_PHN68_sram_din_49 D<48>=FE_PHN67_sram_din_48
+ D<47>=FE_PHN70_sram_din_47 D<46>=FE_PHN69_sram_din_46
+ D<45>=FE_PHN71_sram_din_45 D<44>=FE_PHN83_sram_din_44
+ D<43>=FE_PHN82_sram_din_43 D<42>=FE_PHN84_sram_din_42
+ D<41>=FE_PHN87_sram_din_41 D<40>=FE_PHN85_sram_din_40
+ D<39>=FE_PHN88_sram_din_39 D<38>=FE_PHN162_sram_din_38
+ D<37>=FE_PHN163_sram_din_37 D<36>=FE_PHN161_sram_din_36
+ D<35>=FE_PHN165_sram_din_35 D<34>=FE_PHN164_sram_din_34
+ D<33>=FE_PHN167_sram_din_33 D<32>=FE_PHN166_sram_din_32
+ D<31>=FE_PHN160_sram_din_31 D<30>=FE_PHN111_sram_din_30
+ D<29>=FE_PHN152_sram_din_29 D<28>=FE_PHN158_sram_din_28
+ D<27>=FE_PHN151_sram_din_27 D<26>=FE_PHN153_sram_din_26
+ D<25>=FE_PHN154_sram_din_25 D<24>=FE_PHN155_sram_din_24
+ D<23>=FE_PHN156_sram_din_23 D<22>=FE_PHN157_sram_din_22
+ D<21>=FE_PHN181_sram_din_21 D<20>=FE_PHN182_sram_din_20
+ D<19>=FE_PHN183_sram_din_19 D<18>=FE_PHN235_sram_din_18 D<17>=sram_din<17>
+ D<16>=FE_PHN159_sram_din_16 D<15>=FE_PHN149_sram_din_15
+ D<14>=FE_PHN150_sram_din_14 D<13>=FE_PHN234_sram_din_13
+ D<12>=FE_PHN172_sram_din_12 D<11>=FE_PHN178_sram_din_11
+ D<10>=FE_PHN176_sram_din_10 D<9>=FE_PHN177_sram_din_9 D<8>=FE_PHN232_sram_din_8
+ D<7>=FE_PHN107_sram_din_7 D<6>=FE_PHN223_sram_din_6 D<5>=FE_PHN168_sram_din_5
+ D<4>=FE_PHN170_sram_din_4 D<3>=FE_PHN169_sram_din_3 D<2>=FE_PHN222_sram_din_2
+ D<1>=FE_PHN186_sram_din_1 D<0>=FE_PHN184_sram_din_0 EMA<2>=LTIELO_NET
+ EMA<1>=LTIEHI_NET EMA<0>=LTIELO_NET RETN=LTIEHI_NET VSS=DVSS VDD=DVDD
Xp70817A__2398 ND4D1 $PINS A1=FE_OFN7_n_43 A2=n_30 A3=n_41 A4=n_40
+ ZN=FE_OFN13_bus_dout_2 VSS=DVSS VDD=DVDD
Xp70817A1797__5107 ND4D1 $PINS A1=FE_OFN2_n_22 A2=n_27 A3=n_35 A4=n_20
+ ZN=FE_OFN9_bus_dout_6 VSS=DVSS VDD=DVDD
Xp70817A1798__6260 ND4D1 $PINS A1=FE_OFN5_n_32 A2=n_18 A3=n_45 A4=FE_PDN16_n_16
+ ZN=FE_OFN8_bus_dout_7 VSS=DVSS VDD=DVDD
Xp70817A1799__4319 ND4D1 $PINS A1=n_39 A2=FE_OFN6_n_36 A3=n_37 A4=n_33
+ ZN=FE_OFN14_bus_dout_1 VSS=DVSS VDD=DVDD
Xp70817A1800__8428 ND4D1 $PINS A1=FE_OFN0_n_15 A2=n_44 A3=n_42 A4=FE_PHN45_n_38
+ ZN=FE_OFN10_bus_dout_5 VSS=DVSS VDD=DVDD
Xp70817A1801__5526 ND4D1 $PINS A1=n_31 A2=FE_OFN4_n_26 A3=n_28 A4=n_24
+ ZN=FE_OFN15_bus_dout_0 VSS=DVSS VDD=DVDD
Xp70817A1802__6783 ND4D1 $PINS A1=n_34 A2=FE_OFN3_n_25 A3=FE_PHN44_n_14 A4=n_23
+ ZN=FE_OFN11_bus_dout_4 VSS=DVSS VDD=DVDD
Xp70817A1803__3680 ND4D1 $PINS A1=FE_OFN1_n_21 A2=n_19 A3=n_17 A4=n_29
+ ZN=FE_OFN12_bus_dout_3 VSS=DVSS VDD=DVDD
Xp70812A__1617 AOI22D0 $PINS A1=sram_q<23> A2=n_6 B1=sram_q<31> B2=n_9 ZN=n_45
+ VSS=DVSS VDD=DVDD
Xp70816A__2802 AOI22D1 $PINS A1=sram_q<37> A2=n_8 B1=sram_q<45> B2=n_7 ZN=n_44
+ VSS=DVSS VDD=DVDD
Xp70824A__1705 AOI22D0 $PINS A1=sram_q<50> A2=n_10 B1=sram_q<58> B2=n_13
+ ZN=n_43 VSS=DVSS VDD=DVDD
Xp70812A1804__5122 AOI22D0 $PINS A1=sram_q<21> A2=n_6 B1=sram_q<29> B2=n_9
+ ZN=n_42 VSS=DVSS VDD=DVDD
Xp70812A1805__8246 AOI22D1 $PINS A1=sram_q<34> A2=n_8 B1=sram_q<42> B2=n_7
+ ZN=n_41 VSS=DVSS VDD=DVDD
Xp70810A__7098 AOI22D1 $PINS A1=n_65 A2=n_12 B1=sram_q<10> B2=n_11 ZN=n_40
+ VSS=DVSS VDD=DVDD
Xp70824A1806__6131 AOI22D1 $PINS A1=sram_q<33> A2=n_8 B1=sram_q<41> B2=n_7
+ ZN=n_39 VSS=DVSS VDD=DVDD
Xp70810A1807__1881 AOI22D0 $PINS A1=n_62 A2=n_12 B1=sram_q<13> B2=n_11 ZN=n_38
+ VSS=DVSS VDD=DVDD
Xp70812A1808__5115 AOI22D0 $PINS A1=sram_q<17> A2=n_6 B1=sram_q<25> B2=n_9
+ ZN=n_37 VSS=DVSS VDD=DVDD
Xp70816A1809__7482 AOI22D0 $PINS A1=sram_q<49> A2=n_10 B1=sram_q<57> B2=n_13
+ ZN=n_36 VSS=DVSS VDD=DVDD
Xp70812A1810__4733 AOI22D1 $PINS A1=n_61 A2=n_12 B1=sram_q<14> B2=n_11 ZN=n_35
+ VSS=DVSS VDD=DVDD
Xp70824A1811__6161 AOI22D0 $PINS A1=sram_q<20> A2=n_6 B1=sram_q<28> B2=n_9
+ ZN=n_34 VSS=DVSS VDD=DVDD
Xp70810A1812__9315 AOI22D0 $PINS A1=n_66 A2=n_12 B1=sram_q<9> B2=n_11 ZN=n_33
+ VSS=DVSS VDD=DVDD
Xp70824A1813__9945 AOI22D0 $PINS A1=sram_q<55> A2=n_10 B1=sram_q<63> B2=n_13
+ ZN=n_32 VSS=DVSS VDD=DVDD
Xp70824A1814__2883 AOI22D1 $PINS A1=sram_q<32> A2=n_8 B1=sram_q<40> B2=n_7
+ ZN=n_31 VSS=DVSS VDD=DVDD
Xp70816A1815__2346 AOI22D0 $PINS A1=sram_q<18> A2=n_6 B1=sram_q<26> B2=n_9
+ ZN=n_30 VSS=DVSS VDD=DVDD
Xp70810A1816__1666 AOI22D1 $PINS A1=n_64 A2=n_12 B1=sram_q<11> B2=n_11 ZN=n_29
+ VSS=DVSS VDD=DVDD
Xp70812A1817__7410 AOI22D0 $PINS A1=sram_q<16> A2=n_6 B1=sram_q<24> B2=n_9
+ ZN=n_28 VSS=DVSS VDD=DVDD
Xp70816A1818__6417 AOI22D0 $PINS A1=sram_q<22> A2=n_6 B1=sram_q<30> B2=n_9
+ ZN=n_27 VSS=DVSS VDD=DVDD
Xp70816A1819__5477 AOI22D0 $PINS A1=sram_q<48> A2=n_10 B1=sram_q<56> B2=n_13
+ ZN=n_26 VSS=DVSS VDD=DVDD
Xp70816A1820__2398 AOI22D0 $PINS A1=sram_q<52> A2=n_10 B1=sram_q<60> B2=n_13
+ ZN=n_25 VSS=DVSS VDD=DVDD
Xp70810A1821__5107 AOI22D0 $PINS A1=n_67 A2=n_12 B1=sram_q<8> B2=n_11 ZN=n_24
+ VSS=DVSS VDD=DVDD
Xp70810A1822__6260 AOI22D1 $PINS A1=sram_q<36> A2=n_8 B1=sram_q<44> B2=n_7
+ ZN=n_23 VSS=DVSS VDD=DVDD
Xp70824A1823__4319 AOI22D0 $PINS A1=sram_q<54> A2=n_10 B1=sram_q<62> B2=n_13
+ ZN=n_22 VSS=DVSS VDD=DVDD
Xp70824A1824__8428 AOI22D0 $PINS A1=sram_q<51> A2=n_10 B1=sram_q<59> B2=n_13
+ ZN=n_21 VSS=DVSS VDD=DVDD
Xp70810A1825__5526 AOI22D1 $PINS A1=sram_q<38> A2=n_8 B1=sram_q<46> B2=n_7
+ ZN=n_20 VSS=DVSS VDD=DVDD
Xp70816A1826__6783 AOI22D1 $PINS A1=sram_q<35> A2=n_8 B1=sram_q<43> B2=n_7
+ ZN=n_19 VSS=DVSS VDD=DVDD
Xp70816A1827__3680 AOI22D1 $PINS A1=sram_q<39> A2=n_8 B1=sram_q<47> B2=n_7
+ ZN=n_18 VSS=DVSS VDD=DVDD
Xp70812A1828__1617 AOI22D0 $PINS A1=sram_q<19> A2=n_6 B1=sram_q<27> B2=n_9
+ ZN=n_17 VSS=DVSS VDD=DVDD
Xp70810A1829__2802 AOI22D0 $PINS A1=n_60 A2=n_12 B1=sram_q<15> B2=n_11 ZN=n_16
+ VSS=DVSS VDD=DVDD
Xp70824A1830__1705 AOI22D0 $PINS A1=sram_q<53> A2=n_10 B1=sram_q<61> B2=n_13
+ ZN=n_15 VSS=DVSS VDD=DVDD
Xp70812A1831__5122 AOI22D0 $PINS A1=n_63 A2=n_12 B1=sram_q<12> B2=n_11 ZN=n_14
+ VSS=DVSS VDD=DVDD
Xp71871A__8246 NR2D2 $PINS A1=n_2 A2=n_1 ZN=n_13 VSS=DVSS VDD=DVDD
Xp71849A__7098 INR2D0 $PINS A1=n_5 B1=FE_PHN36_bus_byte_sel_d1_0 ZN=n_12
+ VSS=DVSS VDD=DVDD
Xp71898A__6131 CKAN2D0 $PINS A1=n_5 A2=FE_PHN36_bus_byte_sel_d1_0 Z=n_11
+ VSS=DVSS VDD=DVDD
Xp71884A__1881 NR2XD1 $PINS A1=n_2 A2=FE_PHN36_bus_byte_sel_d1_0 ZN=n_10
+ VSS=DVSS VDD=DVDD
Xp71849A1832__5115 NR2D1 $PINS A1=n_3 A2=n_1 ZN=n_9 VSS=DVSS VDD=DVDD
Xp71859A__7482 NR2D1 $PINS A1=n_4 A2=FE_PHN36_bus_byte_sel_d1_0 ZN=n_8 VSS=DVSS
+ VDD=DVDD
Xp71846A__4733 NR2D1 $PINS A1=n_4 A2=n_1 ZN=n_7 VSS=DVSS VDD=DVDD
Xp71862A__6161 NR2D1 $PINS A1=n_3 A2=FE_PHN36_bus_byte_sel_d1_0 ZN=n_6 VSS=DVSS
+ VDD=DVDD
Xp71824A__9315 NR2D0 $PINS A1=FE_PHN38_bus_byte_sel_d1_2
+ A2=FE_PHN37_bus_byte_sel_d1_1 ZN=n_5 VSS=DVSS VDD=DVDD
Xp71822A__9945 IND2D0 $PINS A1=FE_PHN37_bus_byte_sel_d1_1
+ B1=FE_PHN38_bus_byte_sel_d1_2 ZN=n_4 VSS=DVSS VDD=DVDD
Xp71825A__2883 IND2D0 $PINS A1=FE_PHN38_bus_byte_sel_d1_2
+ B1=FE_PHN37_bus_byte_sel_d1_1 ZN=n_3 VSS=DVSS VDD=DVDD
Xp71861A__2346 CKND2D0 $PINS A1=FE_PHN37_bus_byte_sel_d1_1
+ A2=FE_PHN38_bus_byte_sel_d1_2 ZN=n_2 VSS=DVSS VDD=DVDD
Xbus_byte_sel_d1_reg[2] DFCNQD1 $PINS CDN=FE_PHN51_rstn CP=CTS_1
+ D=FE_PHN23_bus_addr_2 Q=bus_byte_sel_d1<2> VSS=DVSS VDD=DVDD
Xbus_byte_sel_d1_reg[1] DFCNQD1 $PINS CDN=FE_PHN51_rstn CP=CTS_1
+ D=FE_PHN145_bus_addr_1 Q=bus_byte_sel_d1<1> VSS=DVSS VDD=DVDD
Xp96144A__1666 AO22D0 $PINS A1=n_0 A2=bus_addr<8> B1=tpu_addr<5>
+ B2=FE_PHN40_tpu_we Z=sram_addr<5> VSS=DVSS VDD=DVDD
Xp96144A1087__7410 AO22D0 $PINS A1=n_0 A2=FE_PHN191_bus_addr_10 B1=tpu_addr<7>
+ B2=FE_PHN40_tpu_we Z=sram_addr<7> VSS=DVSS VDD=DVDD
Xp96144A1088__6417 AO22D0 $PINS A1=n_0 A2=FE_PHN190_bus_addr_11 B1=tpu_addr<8>
+ B2=FE_PHN40_tpu_we Z=sram_addr<8> VSS=DVSS VDD=DVDD
Xp96144A1089__5477 AO22D0 $PINS A1=n_0 A2=FE_PHN192_bus_addr_5 B1=tpu_addr<2>
+ B2=FE_PHN40_tpu_we Z=sram_addr<2> VSS=DVSS VDD=DVDD
Xp96144A1090__2398 AO22D0 $PINS A1=n_0 A2=bus_addr<3> B1=tpu_addr<0>
+ B2=FE_PHN40_tpu_we Z=sram_addr<0> VSS=DVSS VDD=DVDD
Xp96144A1091__5107 AO22D0 $PINS A1=n_0 A2=bus_addr<7> B1=tpu_addr<4>
+ B2=FE_PHN40_tpu_we Z=sram_addr<4> VSS=DVSS VDD=DVDD
Xp96144A1092__6260 AO22D0 $PINS A1=n_0 A2=bus_addr<4> B1=tpu_addr<1>
+ B2=FE_PHN40_tpu_we Z=sram_addr<1> VSS=DVSS VDD=DVDD
Xp96144A1093__4319 AO22D0 $PINS A1=n_0 A2=bus_addr<9> B1=tpu_addr<6>
+ B2=FE_PHN40_tpu_we Z=sram_addr<6> VSS=DVSS VDD=DVDD
Xp96144A1094__8428 AO22D0 $PINS A1=n_0 A2=bus_addr<6> B1=tpu_addr<3>
+ B2=FE_PHN40_tpu_we Z=sram_addr<3> VSS=DVSS VDD=DVDD
Xp96447A__5526 AN2XD1 $PINS A1=FE_PHN40_tpu_we A2=FE_PHN18_tpu_din_15
+ Z=sram_din<15> VSS=DVSS VDD=DVDD
Xp96447A1095__6783 CKAN2D0 $PINS A1=FE_PHN40_tpu_we A2=FE_PHN26_tpu_din_24
+ Z=sram_din<24> VSS=DVSS VDD=DVDD
Xp96447A1096__3680 CKAN2D0 $PINS A1=FE_PHN40_tpu_we A2=FE_PHN27_tpu_din_23
+ Z=sram_din<23> VSS=DVSS VDD=DVDD
Xp96447A1097__1617 CKAN2D0 $PINS A1=FE_PHN40_tpu_we A2=tpu_din<55>
+ Z=FE_PHN197_sram_din_55 VSS=DVSS VDD=DVDD
Xp96447A1098__2802 CKAN2D0 $PINS A1=FE_PHN40_tpu_we A2=FE_PHN28_tpu_din_22
+ Z=sram_din<22> VSS=DVSS VDD=DVDD
Xp96447A1099__1705 CKAN2D0 $PINS A1=FE_PHN40_tpu_we A2=FE_PHN30_tpu_din_21
+ Z=sram_din<21> VSS=DVSS VDD=DVDD
Xp96447A1100__5122 CKAN2D0 $PINS A1=FE_PHN40_tpu_we A2=tpu_din<54>
+ Z=sram_din<54> VSS=DVSS VDD=DVDD
Xp96447A1101__8246 CKAN2D0 $PINS A1=FE_PHN40_tpu_we A2=FE_PHN33_tpu_din_20
+ Z=sram_din<20> VSS=DVSS VDD=DVDD
Xp96447A1102__7098 CKAN2D0 $PINS A1=FE_PHN40_tpu_we A2=FE_PHN31_tpu_din_19
+ Z=sram_din<19> VSS=DVSS VDD=DVDD
Xp96447A1103__6131 CKAN2D0 $PINS A1=FE_PHN40_tpu_we A2=tpu_din<53>
+ Z=FE_PHN202_sram_din_53 VSS=DVSS VDD=DVDD
Xp96447A1104__1881 CKAN2D0 $PINS A1=FE_PHN40_tpu_we A2=FE_PHN35_tpu_din_18
+ Z=sram_din<18> VSS=DVSS VDD=DVDD
Xp96447A1105__5115 AN2XD1 $PINS A1=FE_PHN40_tpu_we A2=tpu_din<10>
+ Z=sram_din<10> VSS=DVSS VDD=DVDD
Xp96447A1106__7482 CKAN2D0 $PINS A1=FE_PHN40_tpu_we A2=FE_PHN39_tpu_din_17
+ Z=sram_din<17> VSS=DVSS VDD=DVDD
Xp96447A1107__4733 CKAN2D0 $PINS A1=FE_PHN40_tpu_we A2=tpu_din<52>
+ Z=sram_din<52> VSS=DVSS VDD=DVDD
Xp96447A1108__6161 AN2XD1 $PINS A1=FE_PHN40_tpu_we A2=tpu_din<12>
+ Z=sram_din<12> VSS=DVSS VDD=DVDD
Xp96447A1109__9315 CKAN2D0 $PINS A1=FE_PHN40_tpu_we A2=FE_PHN32_tpu_din_16
+ Z=sram_din<16> VSS=DVSS VDD=DVDD
Xp96447A1110__9945 CKAN2D0 $PINS A1=FE_PHN40_tpu_we A2=tpu_din<56>
+ Z=sram_din<56> VSS=DVSS VDD=DVDD
Xp96447A1111__2883 CKAN2D0 $PINS A1=FE_PHN40_tpu_we A2=tpu_din<51>
+ Z=FE_PHN201_sram_din_51 VSS=DVSS VDD=DVDD
Xp96447A1112__2346 AN2XD1 $PINS A1=FE_PHN40_tpu_we A2=FE_PHN20_tpu_din_14
+ Z=sram_din<14> VSS=DVSS VDD=DVDD
Xp96447A1113__1666 AN2XD1 $PINS A1=FE_PHN40_tpu_we A2=tpu_din<13>
+ Z=sram_din<13> VSS=DVSS VDD=DVDD
Xp96447A1114__7410 CKAN2D0 $PINS A1=FE_PHN40_tpu_we A2=tpu_din<50>
+ Z=sram_din<50> VSS=DVSS VDD=DVDD
Xp96447A1115__6417 AN2XD1 $PINS A1=FE_PHN40_tpu_we A2=tpu_din<11>
+ Z=sram_din<11> VSS=DVSS VDD=DVDD
Xp96447A1116__5477 CKAN2D0 $PINS A1=FE_PHN40_tpu_we A2=tpu_din<49>
+ Z=sram_din<49> VSS=DVSS VDD=DVDD
Xp96447A1117__2398 AN2XD1 $PINS A1=FE_PHN40_tpu_we A2=tpu_din<9> Z=sram_din<9>
+ VSS=DVSS VDD=DVDD
Xp96447A1118__5107 CKAN2D0 $PINS A1=FE_PHN40_tpu_we A2=tpu_din<48>
+ Z=sram_din<48> VSS=DVSS VDD=DVDD
Xp96447A1119__6260 AN2XD1 $PINS A1=FE_PHN40_tpu_we A2=tpu_din<8> Z=sram_din<8>
+ VSS=DVSS VDD=DVDD
Xp96447A1120__4319 AN2XD1 $PINS A1=FE_PHN40_tpu_we A2=tpu_din<7> Z=sram_din<7>
+ VSS=DVSS VDD=DVDD
Xp96447A1121__8428 CKAN2D0 $PINS A1=FE_PHN40_tpu_we A2=tpu_din<47>
+ Z=FE_PHN217_sram_din_47 VSS=DVSS VDD=DVDD
Xp96447A1122__5526 AN2XD1 $PINS A1=FE_PHN40_tpu_we A2=tpu_din<6> Z=sram_din<6>
+ VSS=DVSS VDD=DVDD
Xp96447A1123__6783 AN2XD1 $PINS A1=FE_PHN40_tpu_we A2=tpu_din<5> Z=sram_din<5>
+ VSS=DVSS VDD=DVDD
Xp96447A1124__3680 CKAN2D0 $PINS A1=FE_PHN40_tpu_we A2=tpu_din<46>
+ Z=sram_din<46> VSS=DVSS VDD=DVDD
Xp96447A1125__1617 AN2XD1 $PINS A1=FE_PHN40_tpu_we A2=tpu_din<4> Z=sram_din<4>
+ VSS=DVSS VDD=DVDD
Xp96447A1126__2802 CKAN2D0 $PINS A1=FE_PHN40_tpu_we A2=tpu_din<62>
+ Z=sram_din<62> VSS=DVSS VDD=DVDD
Xp96447A1127__1705 CKAN2D0 $PINS A1=FE_PHN40_tpu_we A2=tpu_din<45>
+ Z=FE_PHN209_sram_din_45 VSS=DVSS VDD=DVDD
Xp96447A1128__5122 AN2XD1 $PINS A1=FE_PHN40_tpu_we A2=tpu_din<2> Z=sram_din<2>
+ VSS=DVSS VDD=DVDD
Xp96447A1129__8246 AN2XD1 $PINS A1=FE_PHN40_tpu_we A2=tpu_din<1> Z=sram_din<1>
+ VSS=DVSS VDD=DVDD
Xp96447A1130__7098 CKAN2D0 $PINS A1=FE_PHN40_tpu_we A2=tpu_din<44>
+ Z=sram_din<44> VSS=DVSS VDD=DVDD
Xp96447A1131__6131 AN2XD1 $PINS A1=FE_PHN40_tpu_we A2=tpu_din<0> Z=sram_din<0>
+ VSS=DVSS VDD=DVDD
Xp96447A1132__1881 CKAN2D0 $PINS A1=FE_PHN40_tpu_we A2=tpu_din<43>
+ Z=FE_PHN213_sram_din_43 VSS=DVSS VDD=DVDD
Xp96447A1133__5115 CKAN2D0 $PINS A1=FE_PHN40_tpu_we A2=tpu_din<42>
+ Z=FE_PHN218_sram_din_42 VSS=DVSS VDD=DVDD
Xp96447A1134__7482 CKAN2D0 $PINS A1=FE_PHN40_tpu_we A2=tpu_din<41>
+ Z=FE_PHN210_sram_din_41 VSS=DVSS VDD=DVDD
Xp96447A1135__4733 CKAN2D0 $PINS A1=FE_PHN40_tpu_we A2=FE_PHN16_tpu_din_30
+ Z=sram_din<30> VSS=DVSS VDD=DVDD
Xp96407A__6161 NR2D0 $PINS A1=FE_PHN40_tpu_we A2=bus_re ZN=sram_cen VSS=DVSS
+ VDD=DVDD
Xp96447A1136__9315 CKAN2D0 $PINS A1=FE_PHN40_tpu_we A2=tpu_din<40>
+ Z=sram_din<40> VSS=DVSS VDD=DVDD
Xp96447A1137__9945 CKAN2D0 $PINS A1=FE_PHN40_tpu_we A2=tpu_din<39>
+ Z=sram_din<39> VSS=DVSS VDD=DVDD
Xp96447A1138__2883 CKAN2D0 $PINS A1=FE_PHN110_tpu_we A2=tpu_din<63>
+ Z=sram_din<63> VSS=DVSS VDD=DVDD
Xp96447A1139__2346 CKAN2D0 $PINS A1=FE_PHN40_tpu_we A2=tpu_din<38>
+ Z=FE_PHN212_sram_din_38 VSS=DVSS VDD=DVDD
Xp96447A1140__1666 CKAN2D0 $PINS A1=FE_PHN40_tpu_we A2=tpu_din<37>
+ Z=FE_PHN216_sram_din_37 VSS=DVSS VDD=DVDD
Xp96447A1141__7410 AN2XD1 $PINS A1=FE_PHN40_tpu_we A2=tpu_din<3> Z=sram_din<3>
+ VSS=DVSS VDD=DVDD
Xp96447A1142__6417 AN2D2 $PINS A1=FE_PHN40_tpu_we A2=tpu_din<36> Z=sram_din<36>
+ VSS=DVSS VDD=DVDD
Xp96447A1143__5477 CKAN2D0 $PINS A1=FE_PHN40_tpu_we A2=tpu_din<35>
+ Z=FE_PHN220_sram_din_35 VSS=DVSS VDD=DVDD
Xp96447A1144__2398 CKAN2D0 $PINS A1=FE_PHN40_tpu_we A2=tpu_din<61>
+ Z=sram_din<61> VSS=DVSS VDD=DVDD
Xp96447A1145__5107 CKAN2D0 $PINS A1=FE_PHN40_tpu_we A2=tpu_din<34>
+ Z=FE_PHN219_sram_din_34 VSS=DVSS VDD=DVDD
Xp96447A1146__6260 CKAN2D0 $PINS A1=FE_PHN40_tpu_we A2=tpu_din<33>
+ Z=FE_PHN221_sram_din_33 VSS=DVSS VDD=DVDD
Xp96447A1147__4319 CKAN2D0 $PINS A1=FE_PHN40_tpu_we A2=tpu_din<60>
+ Z=sram_din<60> VSS=DVSS VDD=DVDD
Xp96447A1148__8428 CKAN2D0 $PINS A1=FE_PHN40_tpu_we A2=tpu_din<32>
+ Z=FE_PHN214_sram_din_32 VSS=DVSS VDD=DVDD
Xp96447A1149__5526 CKAN2D0 $PINS A1=FE_PHN40_tpu_we A2=FE_PHN34_tpu_din_31
+ Z=sram_din<31> VSS=DVSS VDD=DVDD
Xp96447A1150__6783 CKAN2D0 $PINS A1=FE_PHN40_tpu_we A2=tpu_din<59>
+ Z=sram_din<59> VSS=DVSS VDD=DVDD
Xp96447A1151__3680 CKAN2D0 $PINS A1=FE_PHN40_tpu_we A2=FE_PHN19_tpu_din_29
+ Z=sram_din<29> VSS=DVSS VDD=DVDD
Xp96447A1152__1617 CKAN2D0 $PINS A1=FE_PHN40_tpu_we A2=tpu_din<58>
+ Z=sram_din<58> VSS=DVSS VDD=DVDD
Xp96447A1153__2802 CKAN2D0 $PINS A1=FE_PHN40_tpu_we A2=FE_PHN29_tpu_din_28
+ Z=sram_din<28> VSS=DVSS VDD=DVDD
Xp96447A1154__1705 CKAN2D0 $PINS A1=FE_PHN40_tpu_we A2=FE_PHN17_tpu_din_27
+ Z=sram_din<27> VSS=DVSS VDD=DVDD
Xp96447A1155__5122 CKAN2D0 $PINS A1=FE_PHN40_tpu_we A2=tpu_din<57>
+ Z=sram_din<57> VSS=DVSS VDD=DVDD
Xp96447A1156__8246 CKAN2D0 $PINS A1=FE_PHN40_tpu_we A2=FE_PHN21_tpu_din_26
+ Z=sram_din<26> VSS=DVSS VDD=DVDD
Xp96447A1157__7098 CKAN2D0 $PINS A1=FE_PHN40_tpu_we A2=FE_PHN25_tpu_din_25
+ Z=sram_din<25> VSS=DVSS VDD=DVDD
XFp96144A1836 CKND0 $PINS I=FE_PHN40_tpu_we ZN=n_0 VSS=DVSS VDD=DVDD
Xbus_byte_sel_d1_reg[0] DFCND1 $PINS CDN=FE_PHN108_rstn CP=CTS_1
+ D=FE_PHN142_bus_addr_0 Q=bus_byte_sel_d1<0> QN=n_1 VSS=DVSS VDD=DVDD
XFILLER_T_1_610 DCAP4 $PINS VSS=DVSS VDD=DVDD
XFILLER_T_1_609 DCAP8 $PINS VSS=DVSS VDD=DVDD
XFILLER_T_1_608 DCAP64 $PINS VSS=DVSS VDD=DVDD
XFILLER_T_1_607 DCAP64 $PINS VSS=DVSS VDD=DVDD
XFILLER_T_1_604 DCAP4 $PINS VSS=DVSS VDD=DVDD
XFILLER_T_1_602 DCAP4 $PINS VSS=DVSS VDD=DVDD
XFILLER_T_1_601 DCAP32 $PINS VSS=DVSS VDD=DVDD
XFILLER_T_1_600 DCAP64 $PINS VSS=DVSS VDD=DVDD
XFILLER_T_1_597 DCAP8 $PINS VSS=DVSS VDD=DVDD
XFILLER_T_1_596 DCAP32 $PINS VSS=DVSS VDD=DVDD
XFILLER_T_1_595 DCAP64 $PINS VSS=DVSS VDD=DVDD
XFILLER_T_1_594 DCAP64 $PINS VSS=DVSS VDD=DVDD
XFILLER_T_1_590 DCAP4 $PINS VSS=DVSS VDD=DVDD
XFILLER_T_1_587 DCAP4 $PINS VSS=DVSS VDD=DVDD
XFILLER_T_1_580 DCAP4 $PINS VSS=DVSS VDD=DVDD
XFILLER_T_1_571 DCAP4 $PINS VSS=DVSS VDD=DVDD
XFILLER_T_1_566 DCAP4 $PINS VSS=DVSS VDD=DVDD
XFILLER_T_1_558 DCAP4 $PINS VSS=DVSS VDD=DVDD
XFILLER_T_1_551 DCAP4 $PINS VSS=DVSS VDD=DVDD
XFILLER_T_1_542 DCAP4 $PINS VSS=DVSS VDD=DVDD
XFILLER_T_1_541 DCAP16 $PINS VSS=DVSS VDD=DVDD
XFILLER_T_1_538 DCAP8 $PINS VSS=DVSS VDD=DVDD
XFILLER_T_1_537 DCAP16 $PINS VSS=DVSS VDD=DVDD
XFILLER_T_1_535 DCAP8 $PINS VSS=DVSS VDD=DVDD
XFILLER_T_1_533 DCAP4 $PINS VSS=DVSS VDD=DVDD
XFILLER_T_1_532 DCAP16 $PINS VSS=DVSS VDD=DVDD
XFILLER_T_1_531 DCAP64 $PINS VSS=DVSS VDD=DVDD
XFILLER_T_1_530 DCAP64 $PINS VSS=DVSS VDD=DVDD
XFILLER_T_1_527 DCAP4 $PINS VSS=DVSS VDD=DVDD
XFILLER_T_1_526 DCAP16 $PINS VSS=DVSS VDD=DVDD
XFILLER_T_1_525 DCAP32 $PINS VSS=DVSS VDD=DVDD
XFILLER_T_1_524 DCAP64 $PINS VSS=DVSS VDD=DVDD
XFILLER_T_1_521 DCAP32 $PINS VSS=DVSS VDD=DVDD
XFILLER_T_1_520 DCAP4 $PINS VSS=DVSS VDD=DVDD
XFILLER_T_1_514 DCAP4 $PINS VSS=DVSS VDD=DVDD
XFILLER_T_1_513 DCAP16 $PINS VSS=DVSS VDD=DVDD
XFILLER_T_1_510 DCAP4 $PINS VSS=DVSS VDD=DVDD
XFILLER_T_1_507 DCAP4 $PINS VSS=DVSS VDD=DVDD
XFILLER_T_1_505 DCAP4 $PINS VSS=DVSS VDD=DVDD
XFILLER_T_1_496 DCAP4 $PINS VSS=DVSS VDD=DVDD
XFILLER_T_1_494 DCAP8 $PINS VSS=DVSS VDD=DVDD
XFILLER_T_1_486 DCAP4 $PINS VSS=DVSS VDD=DVDD
XFILLER_T_1_473 DCAP4 $PINS VSS=DVSS VDD=DVDD
XFILLER_T_1_471 DCAP8 $PINS VSS=DVSS VDD=DVDD
XFILLER_T_1_465 DCAP4 $PINS VSS=DVSS VDD=DVDD
XFILLER_T_1_463 DCAP4 $PINS VSS=DVSS VDD=DVDD
XFILLER_T_1_460 DCAP16 $PINS VSS=DVSS VDD=DVDD
XFILLER_T_1_457 DCAP4 $PINS VSS=DVSS VDD=DVDD
XFILLER_T_1_456 DCAP16 $PINS VSS=DVSS VDD=DVDD
XFILLER_T_1_453 DCAP4 $PINS VSS=DVSS VDD=DVDD
XFILLER_T_1_449 DCAP64 $PINS VSS=DVSS VDD=DVDD
XFILLER_T_1_447 DCAP64 $PINS VSS=DVSS VDD=DVDD
XFILLER_T_1_441 DCAP8 $PINS VSS=DVSS VDD=DVDD
XFILLER_T_1_438 DCAP8 $PINS VSS=DVSS VDD=DVDD
XFILLER_T_1_437 DCAP16 $PINS VSS=DVSS VDD=DVDD
XFILLER_T_1_436 DCAP8 $PINS VSS=DVSS VDD=DVDD
XFILLER_T_1_435 DCAP32 $PINS VSS=DVSS VDD=DVDD
XFILLER_T_1_433 DCAP4 $PINS VSS=DVSS VDD=DVDD
XFILLER_T_1_429 DCAP4 $PINS VSS=DVSS VDD=DVDD
XFILLER_T_1_427 DCAP4 $PINS VSS=DVSS VDD=DVDD
XFILLER_T_1_415 DCAP8 $PINS VSS=DVSS VDD=DVDD
XFILLER_T_1_401 DCAP4 $PINS VSS=DVSS VDD=DVDD
XFILLER_T_1_395 DCAP8 $PINS VSS=DVSS VDD=DVDD
XFILLER_T_1_386 DCAP4 $PINS VSS=DVSS VDD=DVDD
XFILLER_T_1_384 DCAP16 $PINS VSS=DVSS VDD=DVDD
XFILLER_T_1_383 DCAP32 $PINS VSS=DVSS VDD=DVDD
XFILLER_T_1_382 DCAP64 $PINS VSS=DVSS VDD=DVDD
XFILLER_T_1_381 DCAP64 $PINS VSS=DVSS VDD=DVDD
XFILLER_T_1_372 DCAP8 $PINS VSS=DVSS VDD=DVDD
XFILLER_T_1_364 DCAP4 $PINS VSS=DVSS VDD=DVDD
XFILLER_T_1_363 DCAP8 $PINS VSS=DVSS VDD=DVDD
XFILLER_T_1_362 DCAP16 $PINS VSS=DVSS VDD=DVDD
XFILLER_T_1_359 DCAP32 $PINS VSS=DVSS VDD=DVDD
XFILLER_T_1_353 DCAP4 $PINS VSS=DVSS VDD=DVDD
XFILLER_T_1_348 DCAP4 $PINS VSS=DVSS VDD=DVDD
XFILLER_T_1_344 DCAP4 $PINS VSS=DVSS VDD=DVDD
XFILLER_T_1_333 DCAP4 $PINS VSS=DVSS VDD=DVDD
XFILLER_T_1_328 DCAP8 $PINS VSS=DVSS VDD=DVDD
XFILLER_T_1_308 DCAP8 $PINS VSS=DVSS VDD=DVDD
XFILLER_T_1_305 DCAP8 $PINS VSS=DVSS VDD=DVDD
XFILLER_T_1_300 DCAP4 $PINS VSS=DVSS VDD=DVDD
XFILLER_T_1_297 DCAP16 $PINS VSS=DVSS VDD=DVDD
XFILLER_T_1_294 DCAP4 $PINS VSS=DVSS VDD=DVDD
XFILLER_T_1_293 DCAP8 $PINS VSS=DVSS VDD=DVDD
XFILLER_T_1_290 DCAP4 $PINS VSS=DVSS VDD=DVDD
XFILLER_T_1_289 DCAP8 $PINS VSS=DVSS VDD=DVDD
XFILLER_T_1_286 DCAP4 $PINS VSS=DVSS VDD=DVDD
XFILLER_T_1_285 DCAP8 $PINS VSS=DVSS VDD=DVDD
XFILLER_T_1_282 DCAP4 $PINS VSS=DVSS VDD=DVDD
XFILLER_T_1_281 DCAP8 $PINS VSS=DVSS VDD=DVDD
XFILLER_T_1_278 DCAP4 $PINS VSS=DVSS VDD=DVDD
XFILLER_T_1_277 DCAP8 $PINS VSS=DVSS VDD=DVDD
XFILLER_T_1_274 DCAP4 $PINS VSS=DVSS VDD=DVDD
XFILLER_T_1_273 DCAP8 $PINS VSS=DVSS VDD=DVDD
XFILLER_T_1_270 DCAP4 $PINS VSS=DVSS VDD=DVDD
XFILLER_T_1_269 DCAP8 $PINS VSS=DVSS VDD=DVDD
XFILLER_T_1_266 DCAP4 $PINS VSS=DVSS VDD=DVDD
XFILLER_T_1_265 DCAP8 $PINS VSS=DVSS VDD=DVDD
XFILLER_T_1_262 DCAP4 $PINS VSS=DVSS VDD=DVDD
XFILLER_T_1_261 DCAP8 $PINS VSS=DVSS VDD=DVDD
XFILLER_T_1_258 DCAP4 $PINS VSS=DVSS VDD=DVDD
XFILLER_T_1_257 DCAP8 $PINS VSS=DVSS VDD=DVDD
XFILLER_T_1_254 DCAP4 $PINS VSS=DVSS VDD=DVDD
XFILLER_T_1_253 DCAP8 $PINS VSS=DVSS VDD=DVDD
XFILLER_T_1_250 DCAP4 $PINS VSS=DVSS VDD=DVDD
XFILLER_T_1_249 DCAP8 $PINS VSS=DVSS VDD=DVDD
XFILLER_T_1_246 DCAP4 $PINS VSS=DVSS VDD=DVDD
XFILLER_T_1_245 DCAP8 $PINS VSS=DVSS VDD=DVDD
XFILLER_T_1_242 DCAP4 $PINS VSS=DVSS VDD=DVDD
XFILLER_T_1_241 DCAP8 $PINS VSS=DVSS VDD=DVDD
XFILLER_T_1_238 DCAP4 $PINS VSS=DVSS VDD=DVDD
XFILLER_T_1_237 DCAP8 $PINS VSS=DVSS VDD=DVDD
XFILLER_T_1_234 DCAP4 $PINS VSS=DVSS VDD=DVDD
XFILLER_T_1_233 DCAP8 $PINS VSS=DVSS VDD=DVDD
XFILLER_T_1_230 DCAP4 $PINS VSS=DVSS VDD=DVDD
XFILLER_T_1_229 DCAP8 $PINS VSS=DVSS VDD=DVDD
XFILLER_T_1_226 DCAP4 $PINS VSS=DVSS VDD=DVDD
XFILLER_T_1_225 DCAP8 $PINS VSS=DVSS VDD=DVDD
XFILLER_T_1_222 DCAP4 $PINS VSS=DVSS VDD=DVDD
XFILLER_T_1_221 DCAP8 $PINS VSS=DVSS VDD=DVDD
XFILLER_T_1_218 DCAP4 $PINS VSS=DVSS VDD=DVDD
XFILLER_T_1_217 DCAP8 $PINS VSS=DVSS VDD=DVDD
XFILLER_T_1_214 DCAP4 $PINS VSS=DVSS VDD=DVDD
XFILLER_T_1_213 DCAP8 $PINS VSS=DVSS VDD=DVDD
XFILLER_T_1_210 DCAP4 $PINS VSS=DVSS VDD=DVDD
XFILLER_T_1_209 DCAP8 $PINS VSS=DVSS VDD=DVDD
XFILLER_T_1_206 DCAP4 $PINS VSS=DVSS VDD=DVDD
XFILLER_T_1_205 DCAP8 $PINS VSS=DVSS VDD=DVDD
XFILLER_T_1_202 DCAP4 $PINS VSS=DVSS VDD=DVDD
XFILLER_T_1_201 DCAP8 $PINS VSS=DVSS VDD=DVDD
XFILLER_T_1_198 DCAP4 $PINS VSS=DVSS VDD=DVDD
XFILLER_T_1_197 DCAP8 $PINS VSS=DVSS VDD=DVDD
XFILLER_T_1_194 DCAP4 $PINS VSS=DVSS VDD=DVDD
XFILLER_T_1_193 DCAP8 $PINS VSS=DVSS VDD=DVDD
XFILLER_T_1_190 DCAP4 $PINS VSS=DVSS VDD=DVDD
XFILLER_T_1_189 DCAP8 $PINS VSS=DVSS VDD=DVDD
XFILLER_T_1_186 DCAP4 $PINS VSS=DVSS VDD=DVDD
XFILLER_T_1_185 DCAP8 $PINS VSS=DVSS VDD=DVDD
XFILLER_T_1_182 DCAP4 $PINS VSS=DVSS VDD=DVDD
XFILLER_T_1_181 DCAP8 $PINS VSS=DVSS VDD=DVDD
XFILLER_T_1_178 DCAP4 $PINS VSS=DVSS VDD=DVDD
XFILLER_T_1_177 DCAP8 $PINS VSS=DVSS VDD=DVDD
XFILLER_T_1_174 DCAP4 $PINS VSS=DVSS VDD=DVDD
XFILLER_T_1_173 DCAP8 $PINS VSS=DVSS VDD=DVDD
XFILLER_T_1_170 DCAP4 $PINS VSS=DVSS VDD=DVDD
XFILLER_T_1_169 DCAP8 $PINS VSS=DVSS VDD=DVDD
XFILLER_T_1_166 DCAP4 $PINS VSS=DVSS VDD=DVDD
XFILLER_T_1_165 DCAP8 $PINS VSS=DVSS VDD=DVDD
XFILLER_T_1_162 DCAP4 $PINS VSS=DVSS VDD=DVDD
XFILLER_T_1_161 DCAP8 $PINS VSS=DVSS VDD=DVDD
XFILLER_T_1_158 DCAP4 $PINS VSS=DVSS VDD=DVDD
XFILLER_T_1_157 DCAP8 $PINS VSS=DVSS VDD=DVDD
XFILLER_T_1_154 DCAP4 $PINS VSS=DVSS VDD=DVDD
XFILLER_T_1_153 DCAP8 $PINS VSS=DVSS VDD=DVDD
XFILLER_T_1_150 DCAP4 $PINS VSS=DVSS VDD=DVDD
XFILLER_T_1_149 DCAP8 $PINS VSS=DVSS VDD=DVDD
XFILLER_T_1_146 DCAP4 $PINS VSS=DVSS VDD=DVDD
XFILLER_T_1_145 DCAP8 $PINS VSS=DVSS VDD=DVDD
XFILLER_T_1_142 DCAP4 $PINS VSS=DVSS VDD=DVDD
XFILLER_T_1_141 DCAP8 $PINS VSS=DVSS VDD=DVDD
XFILLER_T_1_138 DCAP4 $PINS VSS=DVSS VDD=DVDD
XFILLER_T_1_137 DCAP8 $PINS VSS=DVSS VDD=DVDD
XFILLER_T_1_134 DCAP4 $PINS VSS=DVSS VDD=DVDD
XFILLER_T_1_133 DCAP8 $PINS VSS=DVSS VDD=DVDD
XFILLER_T_1_130 DCAP4 $PINS VSS=DVSS VDD=DVDD
XFILLER_T_1_129 DCAP8 $PINS VSS=DVSS VDD=DVDD
XFILLER_T_1_126 DCAP4 $PINS VSS=DVSS VDD=DVDD
XFILLER_T_1_125 DCAP8 $PINS VSS=DVSS VDD=DVDD
XFILLER_T_1_122 DCAP4 $PINS VSS=DVSS VDD=DVDD
XFILLER_T_1_121 DCAP8 $PINS VSS=DVSS VDD=DVDD
XFILLER_T_1_118 DCAP4 $PINS VSS=DVSS VDD=DVDD
XFILLER_T_1_117 DCAP8 $PINS VSS=DVSS VDD=DVDD
XFILLER_T_1_114 DCAP4 $PINS VSS=DVSS VDD=DVDD
XFILLER_T_1_113 DCAP8 $PINS VSS=DVSS VDD=DVDD
XFILLER_T_1_110 DCAP4 $PINS VSS=DVSS VDD=DVDD
XFILLER_T_1_109 DCAP8 $PINS VSS=DVSS VDD=DVDD
XFILLER_T_1_106 DCAP4 $PINS VSS=DVSS VDD=DVDD
XFILLER_T_1_105 DCAP8 $PINS VSS=DVSS VDD=DVDD
XFILLER_T_1_102 DCAP4 $PINS VSS=DVSS VDD=DVDD
XFILLER_T_1_101 DCAP8 $PINS VSS=DVSS VDD=DVDD
XFILLER_T_1_98 DCAP4 $PINS VSS=DVSS VDD=DVDD
XFILLER_T_1_97 DCAP8 $PINS VSS=DVSS VDD=DVDD
XFILLER_T_1_94 DCAP4 $PINS VSS=DVSS VDD=DVDD
XFILLER_T_1_93 DCAP8 $PINS VSS=DVSS VDD=DVDD
XFILLER_T_1_90 DCAP4 $PINS VSS=DVSS VDD=DVDD
XFILLER_T_1_89 DCAP8 $PINS VSS=DVSS VDD=DVDD
XFILLER_T_1_86 DCAP4 $PINS VSS=DVSS VDD=DVDD
XFILLER_T_1_85 DCAP8 $PINS VSS=DVSS VDD=DVDD
XFILLER_T_1_82 DCAP4 $PINS VSS=DVSS VDD=DVDD
XFILLER_T_1_81 DCAP8 $PINS VSS=DVSS VDD=DVDD
XFILLER_T_1_78 DCAP4 $PINS VSS=DVSS VDD=DVDD
XFILLER_T_1_77 DCAP8 $PINS VSS=DVSS VDD=DVDD
XFILLER_T_1_74 DCAP4 $PINS VSS=DVSS VDD=DVDD
XFILLER_T_1_73 DCAP8 $PINS VSS=DVSS VDD=DVDD
XFILLER_T_1_70 DCAP4 $PINS VSS=DVSS VDD=DVDD
XFILLER_T_1_69 DCAP8 $PINS VSS=DVSS VDD=DVDD
XFILLER_T_1_66 DCAP4 $PINS VSS=DVSS VDD=DVDD
XFILLER_T_1_65 DCAP8 $PINS VSS=DVSS VDD=DVDD
XFILLER_T_1_62 DCAP4 $PINS VSS=DVSS VDD=DVDD
XFILLER_T_1_61 DCAP8 $PINS VSS=DVSS VDD=DVDD
XFILLER_T_1_58 DCAP4 $PINS VSS=DVSS VDD=DVDD
XFILLER_T_1_57 DCAP8 $PINS VSS=DVSS VDD=DVDD
XFILLER_T_1_54 DCAP4 $PINS VSS=DVSS VDD=DVDD
XFILLER_T_1_53 DCAP8 $PINS VSS=DVSS VDD=DVDD
XFILLER_T_1_50 DCAP4 $PINS VSS=DVSS VDD=DVDD
XFILLER_T_1_49 DCAP8 $PINS VSS=DVSS VDD=DVDD
XFILLER_T_1_46 DCAP4 $PINS VSS=DVSS VDD=DVDD
XFILLER_T_1_45 DCAP8 $PINS VSS=DVSS VDD=DVDD
XFILLER_T_1_42 DCAP4 $PINS VSS=DVSS VDD=DVDD
XFILLER_T_1_41 DCAP8 $PINS VSS=DVSS VDD=DVDD
XFILLER_T_1_38 DCAP4 $PINS VSS=DVSS VDD=DVDD
XFILLER_T_1_37 DCAP8 $PINS VSS=DVSS VDD=DVDD
XFILLER_T_1_34 DCAP4 $PINS VSS=DVSS VDD=DVDD
XFILLER_T_1_33 DCAP8 $PINS VSS=DVSS VDD=DVDD
XFILLER_T_1_30 DCAP4 $PINS VSS=DVSS VDD=DVDD
XFILLER_T_1_29 DCAP8 $PINS VSS=DVSS VDD=DVDD
XFILLER_T_1_26 DCAP4 $PINS VSS=DVSS VDD=DVDD
XFILLER_T_1_25 DCAP8 $PINS VSS=DVSS VDD=DVDD
XFILLER_T_1_22 DCAP4 $PINS VSS=DVSS VDD=DVDD
XFILLER_T_1_21 DCAP8 $PINS VSS=DVSS VDD=DVDD
XFILLER_T_1_18 DCAP4 $PINS VSS=DVSS VDD=DVDD
XFILLER_T_1_17 DCAP8 $PINS VSS=DVSS VDD=DVDD
XFILLER_T_1_14 DCAP4 $PINS VSS=DVSS VDD=DVDD
XFILLER_T_1_13 DCAP8 $PINS VSS=DVSS VDD=DVDD
XFILLER_T_1_10 DCAP4 $PINS VSS=DVSS VDD=DVDD
XFILLER_T_1_9 DCAP8 $PINS VSS=DVSS VDD=DVDD
XFILLER_T_1_6 DCAP4 $PINS VSS=DVSS VDD=DVDD
XFILLER_T_1_5 DCAP8 $PINS VSS=DVSS VDD=DVDD
XFILLER_T_1_2 DCAP4 $PINS VSS=DVSS VDD=DVDD
XFILLER_T_1_1 DCAP8 $PINS VSS=DVSS VDD=DVDD
.ENDS
.GLOBAL DVDD
.GLOBAL DVSS
