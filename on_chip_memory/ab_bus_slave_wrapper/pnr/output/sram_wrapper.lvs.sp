$ Spice netlist generated by v2lvs
$ v2024.3_25.13    Thu Aug 1 18:56:55 PDT 2024
.INCLUDE "/courses/ee6350/pdk2023/T-N65-CM-SP-018-K3_MOM/digital/Back_End/spice/tcbn65gplus_200a/tcbn65gplus_200a.spi"
.INCLUDE "../../../SRAM00_gen/sram00.cdl"
*.BUSDELIMITER <

.SUBCKT sram_wrapper clk rstn bus_we bus_addr<11> bus_addr<10> bus_addr<9>
+ bus_addr<8> bus_addr<7> bus_addr<6> bus_addr<5> bus_addr<4> bus_addr<3>
+ bus_addr<2> bus_addr<1> bus_addr<0> bus_din<7> bus_din<6> bus_din<5>
+ bus_din<4> bus_din<3> bus_din<2> bus_din<1> bus_din<0> tpu_re tpu_addr<8>
+ tpu_addr<7> tpu_addr<6> tpu_addr<5> tpu_addr<4> tpu_addr<3> tpu_addr<2>
+ tpu_addr<1> tpu_addr<0> tpu_dout<63> tpu_dout<62> tpu_dout<61> tpu_dout<60>
+ tpu_dout<59> tpu_dout<58> tpu_dout<57> tpu_dout<56> tpu_dout<55> tpu_dout<54>
+ tpu_dout<53> tpu_dout<52> tpu_dout<51> tpu_dout<50> tpu_dout<49> tpu_dout<48>
+ tpu_dout<47> tpu_dout<46> tpu_dout<45> tpu_dout<44> tpu_dout<43> tpu_dout<42>
+ tpu_dout<41> tpu_dout<40> tpu_dout<39> tpu_dout<38> tpu_dout<37> tpu_dout<36>
+ tpu_dout<35> tpu_dout<34> tpu_dout<33> tpu_dout<32> tpu_dout<31> tpu_dout<30>
+ tpu_dout<29> tpu_dout<28> tpu_dout<27> tpu_dout<26> tpu_dout<25> tpu_dout<24>
+ tpu_dout<23> tpu_dout<22> tpu_dout<21> tpu_dout<20> tpu_dout<19> tpu_dout<18>
+ tpu_dout<17> tpu_dout<16> tpu_dout<15> tpu_dout<14> tpu_dout<13> tpu_dout<12>
+ tpu_dout<11> tpu_dout<10> tpu_dout<9> tpu_dout<8> tpu_dout<7> tpu_dout<6>
+ tpu_dout<5> tpu_dout<4> tpu_dout<3> tpu_dout<2> tpu_dout<1> tpu_dout<0> DVDD
+ DVSS
XFE_PDC3_n_32 CKBD0 $PINS I=n_32 Z=FE_PDN3_n_32 VSS=DVSS VDD=DVDD
XFE_PDC692_n_77 BUFFD1 $PINS I=n_77 Z=FE_PDN692_n_77 VSS=DVSS VDD=DVDD
XFE_PDC691_bus_wbuf_2 BUFFD1 $PINS I=bus_wbuf<2> Z=FE_PDN691_bus_wbuf_2
+ VSS=DVSS VDD=DVDD
XFE_PDC690_n_34 CKBD1 $PINS I=n_34 Z=FE_PDN690_n_34 VSS=DVSS VDD=DVDD
XFE_PDC2_n_29 CKBD0 $PINS I=n_29 Z=FE_PDN2_n_29 VSS=DVSS VDD=DVDD
XFE_PHC689_bus_din_4 CKBD1 $PINS I=FE_PHN685_bus_din_4 Z=FE_PHN689_bus_din_4
+ VSS=DVSS VDD=DVDD
XFE_PHC688_n_6 BUFFD1 $PINS I=FE_PHN656_n_6 Z=FE_PHN688_n_6 VSS=DVSS VDD=DVDD
XFE_PHC687_bus_din_4 DEL005 $PINS I=bus_din<4> Z=FE_PHN687_bus_din_4 VSS=DVSS
+ VDD=DVDD
XFE_PHC686_n_6 CKBD0 $PINS I=FE_PHN681_n_6 Z=FE_PHN686_n_6 VSS=DVSS VDD=DVDD
XFE_PHC685_bus_din_4 CKBD0 $PINS I=FE_PHN689_bus_din_4 Z=FE_PHN682_bus_din_4
+ VSS=DVSS VDD=DVDD
XFE_PHC684_bus_din_4 DEL005 $PINS I=FE_PHN683_bus_din_4 Z=FE_PHN684_bus_din_4
+ VSS=DVSS VDD=DVDD
XFE_PHC683_bus_din_4 CKBD0 $PINS I=FE_PHN673_bus_din_4 Z=FE_PHN683_bus_din_4
+ VSS=DVSS VDD=DVDD
XFE_PHC682_bus_din_4 CKBD0 $PINS I=FE_PHN682_bus_din_4 Z=FE_PHN675_bus_din_4
+ VSS=DVSS VDD=DVDD
XFE_PHC681_n_6 CKBD0 $PINS I=FE_PHN677_n_6 Z=FE_PHN681_n_6 VSS=DVSS VDD=DVDD
XFE_PHC680_bus_din_3 BUFFD1 $PINS I=FE_PHN680_bus_din_3 Z=FE_PHN676_bus_din_3
+ VSS=DVSS VDD=DVDD
XFE_PHC679_bus_din_4 CKBD0 $PINS I=FE_PHN684_bus_din_4 Z=FE_PHN679_bus_din_4
+ VSS=DVSS VDD=DVDD
XFE_PHC678_bus_din_4 DEL005 $PINS I=FE_PHN678_bus_din_4 Z=FE_PHN685_bus_din_4
+ VSS=DVSS VDD=DVDD
XFE_PHC677_n_6 CKBD0 $PINS I=FE_PHN686_n_6 Z=FE_PHN674_n_6 VSS=DVSS VDD=DVDD
XFE_PHC676_bus_din_3 CKBD0 $PINS I=FE_PHN676_bus_din_3 Z=FE_PHN672_bus_din_3
+ VSS=DVSS VDD=DVDD
XFE_PHC675_bus_din_4 DEL005 $PINS I=FE_PHN647_bus_din_4 Z=FE_PHN678_bus_din_4
+ VSS=DVSS VDD=DVDD
XFE_PHC674_n_6 CKBD0 $PINS I=FE_PHN671_n_6 Z=FE_PHN677_n_6 VSS=DVSS VDD=DVDD
XFE_PHC673_bus_din_4 CKBD0 $PINS I=FE_PHN637_bus_din_4 Z=FE_PHN673_bus_din_4
+ VSS=DVSS VDD=DVDD
XFE_PHC672_bus_din_3 CKBD0 $PINS I=FE_PHN672_bus_din_3 Z=FE_PHN666_bus_din_3
+ VSS=DVSS VDD=DVDD
XFE_PHC671_n_6 DEL005 $PINS I=FE_PHN668_n_6 Z=FE_PHN671_n_6 VSS=DVSS VDD=DVDD
XFE_PHC670_bus_din_4 DEL005 $PINS I=FE_PHN7_bus_din_4 Z=FE_PHN670_bus_din_4
+ VSS=DVSS VDD=DVDD
XFE_PHC669_bus_din_3 DEL005 $PINS I=FE_PHN669_bus_din_3 Z=FE_PHN680_bus_din_3
+ VSS=DVSS VDD=DVDD
XFE_PHC668_n_6 CKBD0 $PINS I=FE_PHN674_n_6 Z=FE_PHN654_n_6 VSS=DVSS VDD=DVDD
XFE_PHC667_bus_din_4 DEL005 $PINS I=FE_PHN670_bus_din_4 Z=FE_PHN667_bus_din_4
+ VSS=DVSS VDD=DVDD
XFE_PHC666_bus_din_3 CKBD0 $PINS I=FE_PHN666_bus_din_3 Z=FE_PHN662_bus_din_3
+ VSS=DVSS VDD=DVDD
XFE_PHC665_bus_din_4 DEL005 $PINS I=FE_PHN667_bus_din_4 Z=FE_PHN665_bus_din_4
+ VSS=DVSS VDD=DVDD
XFE_PHC664_bus_din_3 CKBD0 $PINS I=FE_PHN662_bus_din_3 Z=FE_PHN664_bus_din_3
+ VSS=DVSS VDD=DVDD
XFE_PHC663_n_6 DEL005 $PINS I=FE_PHN663_n_6 Z=FE_PHN668_n_6 VSS=DVSS VDD=DVDD
XFE_PHC662_bus_din_3 DEL005 $PINS I=FE_PHN658_bus_din_3 Z=FE_PHN669_bus_din_3
+ VSS=DVSS VDD=DVDD
XFE_PHC661_bus_din_4 DEL005 $PINS I=FE_PHN665_bus_din_4 Z=FE_PHN661_bus_din_4
+ VSS=DVSS VDD=DVDD
XFE_PHC660_bus_din_3 DEL005 $PINS I=FE_PHN9_bus_din_3 Z=FE_PHN660_bus_din_3
+ VSS=DVSS VDD=DVDD
XFE_PHC659_n_6 DEL0 $PINS I=n_6 Z=FE_PHN659_n_6 VSS=DVSS VDD=DVDD
XFE_PHC658_bus_din_3 CKBD0 $PINS I=FE_PHN653_bus_din_3 Z=FE_PHN658_bus_din_3
+ VSS=DVSS VDD=DVDD
XFE_PHC657_bus_din_3 CKBD0 $PINS I=FE_PHN660_bus_din_3 Z=FE_PHN657_bus_din_3
+ VSS=DVSS VDD=DVDD
XFE_PHC656_n_6 CKBD0 $PINS I=n_6 Z=FE_PHN656_n_6 VSS=DVSS VDD=DVDD
XFE_PHC655_bus_din_4 DEL005 $PINS I=FE_PHN661_bus_din_4 Z=FE_PHN655_bus_din_4
+ VSS=DVSS VDD=DVDD
XFE_PHC654_n_6 CKBD1 $PINS I=FE_PHN654_n_6 Z=n_6 VSS=DVSS VDD=DVDD
XFE_PHC653_bus_din_3 DEL005 $PINS I=FE_PHN557_bus_din_3 Z=FE_PHN653_bus_din_3
+ VSS=DVSS VDD=DVDD
XFE_PHC652_bus_din_4 DEL005 $PINS I=FE_PHN655_bus_din_4 Z=FE_PHN652_bus_din_4
+ VSS=DVSS VDD=DVDD
XFE_PHC651_n_4 DEL015 $PINS I=n_4 Z=FE_PHN651_n_4 VSS=DVSS VDD=DVDD
XFE_PHC650_n_4 CKBD0 $PINS I=n_4 Z=FE_PHN650_n_4 VSS=DVSS VDD=DVDD
XFE_PHC649_bus_din_6 DEL005 $PINS I=FE_PHN10_bus_din_6 Z=FE_PHN649_bus_din_6
+ VSS=DVSS VDD=DVDD
XFE_PHC648_bus_din_3 CKBD0 $PINS I=FE_PHN657_bus_din_3 Z=FE_PHN648_bus_din_3
+ VSS=DVSS VDD=DVDD
XFE_PHC647_bus_din_4 CKBD0 $PINS I=FE_PHN675_bus_din_4 Z=FE_PHN629_bus_din_4
+ VSS=DVSS VDD=DVDD
XFE_PHC646_bus_we BUFFD0 $PINS I=bus_we Z=FE_PHN646_bus_we VSS=DVSS VDD=DVDD
XFE_PHC645_n_3 DEL0 $PINS I=n_3 Z=FE_PHN645_n_3 VSS=DVSS VDD=DVDD
XFE_PHC644_bus_din_4 CKBD0 $PINS I=FE_PHN629_bus_din_4 Z=FE_PHN644_bus_din_4
+ VSS=DVSS VDD=DVDD
XFE_PHC643_bus_din_3 CKBD1 $PINS I=FE_PHN648_bus_din_3 Z=FE_PHN643_bus_din_3
+ VSS=DVSS VDD=DVDD
XFE_PHC642_n_3 CKBD1 $PINS I=n_3 Z=FE_PHN642_n_3 VSS=DVSS VDD=DVDD
XFE_PHC641_bus_din_6 DEL005 $PINS I=FE_PHN10_bus_din_6 Z=FE_PHN641_bus_din_6
+ VSS=DVSS VDD=DVDD
XFE_PHC640_bus_we CKBD0 $PINS I=FE_PHN646_bus_we Z=FE_PHN640_bus_we VSS=DVSS
+ VDD=DVDD
XFE_PHC639_bus_din_2 DEL005 $PINS I=FE_PHN633_bus_din_2 Z=FE_PHN639_bus_din_2
+ VSS=DVSS VDD=DVDD
XFE_PHC638_n_3 CKBD1 $PINS I=FE_PHN638_n_3 Z=n_3 VSS=DVSS VDD=DVDD
XFE_PHC637_bus_din_4 DEL01 $PINS I=FE_PHN7_bus_din_4 Z=FE_PHN637_bus_din_4
+ VSS=DVSS VDD=DVDD
XFE_PHC636_bus_we DEL005 $PINS I=FE_PHN640_bus_we Z=FE_PHN636_bus_we VSS=DVSS
+ VDD=DVDD
XFE_PHC635_bus_din_3 DEL005 $PINS I=FE_PHN643_bus_din_3 Z=FE_PHN635_bus_din_3
+ VSS=DVSS VDD=DVDD
XFE_PHC634_bus_din_6 CKBD0 $PINS I=FE_PHN641_bus_din_6 Z=FE_PHN634_bus_din_6
+ VSS=DVSS VDD=DVDD
XFE_PHC633_bus_din_2 DEL005 $PINS I=FE_PHN628_bus_din_2 Z=FE_PHN633_bus_din_2
+ VSS=DVSS VDD=DVDD
XFE_PHC632_bus_din_3 DEL005 $PINS I=FE_PHN9_bus_din_3 Z=FE_PHN632_bus_din_3
+ VSS=DVSS VDD=DVDD
XFE_PHC631_bus_din_6 DEL01 $PINS I=FE_PHN634_bus_din_6 Z=FE_PHN631_bus_din_6
+ VSS=DVSS VDD=DVDD
XFE_PHC630_bus_we DEL01 $PINS I=FE_PHN636_bus_we Z=FE_PHN630_bus_we VSS=DVSS
+ VDD=DVDD
XFE_PHC629_bus_din_4 DEL01 $PINS I=FE_PHN652_bus_din_4 Z=FE_PHN647_bus_din_4
+ VSS=DVSS VDD=DVDD
XFE_PHC628_bus_din_2 DEL01 $PINS I=FE_PHN623_bus_din_2 Z=FE_PHN628_bus_din_2
+ VSS=DVSS VDD=DVDD
XFE_PHC627_n_4 CKBD1 $PINS I=FE_PHN627_n_4 Z=n_4 VSS=DVSS VDD=DVDD
XFE_PHC626_bus_din_4 DEL015 $PINS I=FE_PHN679_bus_din_4 Z=FE_PHN626_bus_din_4
+ VSS=DVSS VDD=DVDD
XFE_PHC625_bus_din_6 CKBD1 $PINS I=FE_PHN631_bus_din_6 Z=FE_PHN625_bus_din_6
+ VSS=DVSS VDD=DVDD
XFE_PHC624_bus_we DEL015 $PINS I=FE_PHN630_bus_we Z=FE_PHN624_bus_we VSS=DVSS
+ VDD=DVDD
XFE_PHC623_bus_din_2 DEL015 $PINS I=FE_PHN4_bus_din_2 Z=FE_PHN623_bus_din_2
+ VSS=DVSS VDD=DVDD
XFE_PHC622_bus_din_0 CKBD1 $PINS I=FE_PHN405_bus_din_0 Z=FE_PHN622_bus_din_0
+ VSS=DVSS VDD=DVDD
XFE_PHC621_n_90 DEL01 $PINS I=n_90 Z=FE_PHN621_n_90 VSS=DVSS VDD=DVDD
XFE_PHC620_bus_we CKBD1 $PINS I=FE_PHN611_bus_we Z=FE_PHN620_bus_we VSS=DVSS
+ VDD=DVDD
XFE_PHC619_bus_din_4 CKBD1 $PINS I=FE_PHN619_bus_din_4 Z=FE_PHN7_bus_din_4
+ VSS=DVSS VDD=DVDD
XFE_PHC618_bus_din_6 CKBD1 $PINS I=FE_PHN618_bus_din_6 Z=FE_PHN10_bus_din_6
+ VSS=DVSS VDD=DVDD
XFE_PHC617_bus_din_0 CKBD1 $PINS I=FE_PHN617_bus_din_0 Z=FE_PHN405_bus_din_0
+ VSS=DVSS VDD=DVDD
XFE_PHC616_bus_din_1 DEL1 $PINS I=FE_PHN5_bus_din_1 Z=FE_PHN616_bus_din_1
+ VSS=DVSS VDD=DVDD
XFE_PHC615_bus_addr_10 BUFFD1 $PINS I=FE_PHN395_bus_addr_10
+ Z=FE_PHN615_bus_addr_10 VSS=DVSS VDD=DVDD
XFE_PHC614_bus_addr_0 CKBD1 $PINS I=FE_PHN592_bus_addr_0 Z=FE_PHN614_bus_addr_0
+ VSS=DVSS VDD=DVDD
XFE_PHC613_n_29 DEL0 $PINS I=FE_PDN2_n_29 Z=FE_PHN613_n_29 VSS=DVSS VDD=DVDD
XFE_PHC612_n_77 DEL2 $PINS I=FE_PDN692_n_77 Z=FE_PHN612_n_77 VSS=DVSS VDD=DVDD
XFE_PHC611_bus_we CKBD2 $PINS I=FE_PHN3_bus_we Z=FE_PHN611_bus_we VSS=DVSS
+ VDD=DVDD
XFE_PHC610_rstn BUFFD1 $PINS I=rstn Z=FE_PHN610_rstn VSS=DVSS VDD=DVDD
XFE_PHC609_bus_addr_9 BUFFD1 $PINS I=FE_PHN609_bus_addr_9
+ Z=FE_PHN582_bus_addr_9 VSS=DVSS VDD=DVDD
XFE_PHC608_sram_addr_1 CKBD1 $PINS I=FE_PHN352_sram_addr_1
+ Z=FE_PHN608_sram_addr_1 VSS=DVSS VDD=DVDD
XFE_PHC607_sram_wen BUFFD0 $PINS I=FE_PHN607_sram_wen Z=FE_PHN310_sram_wen
+ VSS=DVSS VDD=DVDD
XFE_PHC606_bus_din_3 DEL0 $PINS I=FE_PHN606_bus_din_3 Z=FE_PHN9_bus_din_3
+ VSS=DVSS VDD=DVDD
XFE_PHC605_bus_din_2 BUFFD2 $PINS I=FE_PHN605_bus_din_2 Z=FE_PHN4_bus_din_2
+ VSS=DVSS VDD=DVDD
XFE_PHC604_bus_din_5 DEL0 $PINS I=FE_PHN8_bus_din_5 Z=FE_PHN604_bus_din_5
+ VSS=DVSS VDD=DVDD
XFE_PHC603_bus_we CKBD0 $PINS I=FE_PHN624_bus_we Z=FE_PHN603_bus_we VSS=DVSS
+ VDD=DVDD
XFE_PHC602_bus_we DEL005 $PINS I=FE_PHN620_bus_we Z=FE_PHN602_bus_we VSS=DVSS
+ VDD=DVDD
XFE_PHC601_bus_we CKBD0 $PINS I=FE_PHN603_bus_we Z=FE_PHN601_bus_we VSS=DVSS
+ VDD=DVDD
XFE_PHC600_bus_we BUFFD0 $PINS I=FE_PHN620_bus_we Z=FE_PHN600_bus_we VSS=DVSS
+ VDD=DVDD
XFE_PHC599_bus_we CKBD0 $PINS I=FE_PHN601_bus_we Z=FE_PHN599_bus_we VSS=DVSS
+ VDD=DVDD
XFE_PHC598_bus_we BUFFD0 $PINS I=FE_PHN620_bus_we Z=FE_PHN598_bus_we VSS=DVSS
+ VDD=DVDD
XFE_PHC597_bus_we CKBD0 $PINS I=FE_PHN599_bus_we Z=FE_PHN597_bus_we VSS=DVSS
+ VDD=DVDD
XFE_PHC596_bus_we CKBD0 $PINS I=FE_PHN597_bus_we Z=FE_PHN596_bus_we VSS=DVSS
+ VDD=DVDD
XFE_PHC595_bus_we DEL005 $PINS I=FE_PHN596_bus_we Z=FE_PHN595_bus_we VSS=DVSS
+ VDD=DVDD
XFE_PHC594_bus_we CKBD0 $PINS I=FE_PHN595_bus_we Z=FE_PHN594_bus_we VSS=DVSS
+ VDD=DVDD
XFE_PHC593_bus_we DEL005 $PINS I=FE_PHN594_bus_we Z=FE_PHN593_bus_we VSS=DVSS
+ VDD=DVDD
XFE_PHC592_bus_addr_0 CKBD1 $PINS I=FE_PHN586_bus_addr_0 Z=FE_PHN592_bus_addr_0
+ VSS=DVSS VDD=DVDD
XFE_PHC591_sram_addr_0 DEL015 $PINS I=FE_PHN354_sram_addr_0
+ Z=FE_PHN591_sram_addr_0 VSS=DVSS VDD=DVDD
XFE_PHC590_n_76 DEL0 $PINS I=n_76 Z=FE_PHN590_n_76 VSS=DVSS VDD=DVDD
XFE_PHC589_bus_we CKBD0 $PINS I=FE_PHN593_bus_we Z=FE_PHN589_bus_we VSS=DVSS
+ VDD=DVDD
XFE_PHC588_bus_wbuf_15 BUFFD1 $PINS I=FE_PHN572_bus_wbuf_15
+ Z=FE_PHN588_bus_wbuf_15 VSS=DVSS VDD=DVDD
XFE_PHC587_bus_addr_7 CKBD1 $PINS I=FE_PHN159_bus_addr_7 Z=FE_PHN587_bus_addr_7
+ VSS=DVSS VDD=DVDD
XFE_PHC586_bus_addr_0 CKBD0 $PINS I=FE_PHN150_bus_addr_0 Z=FE_PHN586_bus_addr_0
+ VSS=DVSS VDD=DVDD
XFE_PHC585_bus_addr_4 CKBD1 $PINS I=FE_PHN158_bus_addr_4 Z=FE_PHN585_bus_addr_4
+ VSS=DVSS VDD=DVDD
XFE_PHC584_bus_addr_3 CKBD1 $PINS I=FE_PHN156_bus_addr_3 Z=FE_PHN584_bus_addr_3
+ VSS=DVSS VDD=DVDD
XFE_PHC583_bus_addr_5 BUFFD1 $PINS I=FE_PHN157_bus_addr_5
+ Z=FE_PHN583_bus_addr_5 VSS=DVSS VDD=DVDD
XFE_PHC582_bus_addr_9 BUFFD1 $PINS I=FE_PHN154_bus_addr_9
+ Z=FE_PHN609_bus_addr_9 VSS=DVSS VDD=DVDD
XFE_PHC581_bus_addr_6 CKBD0 $PINS I=FE_PHN155_bus_addr_6 Z=FE_PHN581_bus_addr_6
+ VSS=DVSS VDD=DVDD
XFE_PHC580_bus_wbuf_8 DEL005 $PINS I=FE_PHN564_bus_wbuf_8
+ Z=FE_PHN580_bus_wbuf_8 VSS=DVSS VDD=DVDD
XFE_PHC579_bus_addr_11 CKBD0 $PINS I=bus_addr<11> Z=FE_PHN579_bus_addr_11
+ VSS=DVSS VDD=DVDD
XFE_PHC578_bus_wbuf_9 CKBD0 $PINS I=FE_PHN578_bus_wbuf_9 Z=FE_PHN571_bus_wbuf_9
+ VSS=DVSS VDD=DVDD
XFE_PHC577_bus_wbuf_51 BUFFD1 $PINS I=FE_PHN341_bus_wbuf_51
+ Z=FE_PHN577_bus_wbuf_51 VSS=DVSS VDD=DVDD
XFE_PHC576_bus_we DEL005 $PINS I=FE_PHN589_bus_we Z=FE_PHN576_bus_we VSS=DVSS
+ VDD=DVDD
XFE_PHC575_bus_wbuf_16 CKBD1 $PINS I=bus_wbuf<16> Z=FE_PHN575_bus_wbuf_16
+ VSS=DVSS VDD=DVDD
XFE_PHC574_n_1 DEL0 $PINS I=FE_PHN574_n_1 Z=n_1 VSS=DVSS VDD=DVDD
XFE_PHC573_bus_addr_0 CKBD0 $PINS I=bus_addr<0> Z=FE_PHN573_bus_addr_0 VSS=DVSS
+ VDD=DVDD
XFE_PHC572_bus_wbuf_15 DEL005 $PINS I=FE_PHN375_bus_wbuf_15
+ Z=FE_PHN572_bus_wbuf_15 VSS=DVSS VDD=DVDD
XFE_PHC571_bus_wbuf_9 CKBD0 $PINS I=FE_PHN571_bus_wbuf_9 Z=bus_wbuf<9> VSS=DVSS
+ VDD=DVDD
XFE_PHC570_bus_addr_8 CKBD1 $PINS I=FE_PHN512_bus_addr_8 Z=FE_PHN570_bus_addr_8
+ VSS=DVSS VDD=DVDD
XFE_PHC569_bus_addr_3 DEL005 $PINS I=bus_addr<3> Z=FE_PHN569_bus_addr_3
+ VSS=DVSS VDD=DVDD
XFE_PHC568_bus_addr_11 DEL005 $PINS I=FE_PHN579_bus_addr_11
+ Z=FE_PHN568_bus_addr_11 VSS=DVSS VDD=DVDD
XFE_PHC567_bus_addr_6 DEL005 $PINS I=bus_addr<6> Z=FE_PHN567_bus_addr_6
+ VSS=DVSS VDD=DVDD
XFE_PHC566_bus_addr_9 DEL005 $PINS I=bus_addr<9> Z=FE_PHN566_bus_addr_9
+ VSS=DVSS VDD=DVDD
XFE_PHC565_bus_addr_5 DEL005 $PINS I=bus_addr<5> Z=FE_PHN565_bus_addr_5
+ VSS=DVSS VDD=DVDD
XFE_PHC564_bus_wbuf_8 DEL005 $PINS I=bus_wbuf<8> Z=FE_PHN564_bus_wbuf_8
+ VSS=DVSS VDD=DVDD
XFE_PHC563_bus_wbuf_10 CKBD1 $PINS I=FE_PHN563_bus_wbuf_10
+ Z=FE_PHN470_bus_wbuf_10 VSS=DVSS VDD=DVDD
XFE_PHC562_bus_addr_4 DEL005 $PINS I=bus_addr<4> Z=FE_PHN562_bus_addr_4
+ VSS=DVSS VDD=DVDD
XFE_PHC561_bus_addr_7 DEL005 $PINS I=bus_addr<7> Z=FE_PHN561_bus_addr_7
+ VSS=DVSS VDD=DVDD
XFE_PHC560_bus_wbuf_1 CKBD0 $PINS I=bus_wbuf<1> Z=FE_PHN560_bus_wbuf_1 VSS=DVSS
+ VDD=DVDD
XFE_PHC559_bus_din_4 DEL005 $PINS I=FE_PHN644_bus_din_4 Z=FE_PHN559_bus_din_4
+ VSS=DVSS VDD=DVDD
XFE_PHC558_bus_addr_1 DEL015 $PINS I=FE_PHN152_bus_addr_1
+ Z=FE_PHN558_bus_addr_1 VSS=DVSS VDD=DVDD
XFE_PHC557_bus_din_3 DEL005 $PINS I=FE_PHN632_bus_din_3 Z=FE_PHN557_bus_din_3
+ VSS=DVSS VDD=DVDD
XFE_PHC556_bus_din_1 DEL005 $PINS I=FE_PHN5_bus_din_1 Z=FE_PHN556_bus_din_1
+ VSS=DVSS VDD=DVDD
XFE_PHC555_sram_addr_0 CKBD0 $PINS I=FE_PHN555_sram_addr_0
+ Z=FE_PHN354_sram_addr_0 VSS=DVSS VDD=DVDD
XFE_PHC554_bus_wbuf_60 DEL015 $PINS I=FE_PHN554_bus_wbuf_60
+ Z=FE_PHN369_bus_wbuf_60 VSS=DVSS VDD=DVDD
XFE_PHC553_bus_wbuf_63 DEL0 $PINS I=FE_PHN553_bus_wbuf_63
+ Z=FE_PHN225_bus_wbuf_63 VSS=DVSS VDD=DVDD
XFE_PHC552_bus_wbuf_59 DEL0 $PINS I=FE_PHN552_bus_wbuf_59
+ Z=FE_PHN224_bus_wbuf_59 VSS=DVSS VDD=DVDD
XFE_PHC551_bus_wbuf_58 DEL0 $PINS I=FE_PHN551_bus_wbuf_58
+ Z=FE_PHN226_bus_wbuf_58 VSS=DVSS VDD=DVDD
XFE_PHC550_sram_addr_3 DEL015 $PINS I=FE_PHN550_sram_addr_3
+ Z=FE_PHN345_sram_addr_3 VSS=DVSS VDD=DVDD
XFE_PHC549_bus_wbuf_61 DEL015 $PINS I=FE_PHN370_bus_wbuf_61
+ Z=FE_PHN549_bus_wbuf_61 VSS=DVSS VDD=DVDD
XFE_PHC548_bus_wbuf_1 CKBD0 $PINS I=FE_PHN548_bus_wbuf_1 Z=FE_PHN367_bus_wbuf_1
+ VSS=DVSS VDD=DVDD
XFE_PHC547_sram_addr_2 DEL01 $PINS I=FE_PHN351_sram_addr_2
+ Z=FE_PHN547_sram_addr_2 VSS=DVSS VDD=DVDD
XFE_PHC546_sram_addr_4 DEL015 $PINS I=FE_PHN546_sram_addr_4
+ Z=FE_PHN320_sram_addr_4 VSS=DVSS VDD=DVDD
XFE_PHC545_sram_addr_1 DEL01 $PINS I=FE_PHN608_sram_addr_1
+ Z=FE_PHN545_sram_addr_1 VSS=DVSS VDD=DVDD
XFE_PHC544_bus_wbuf_62 DEL015 $PINS I=FE_PHN544_bus_wbuf_62
+ Z=FE_PHN371_bus_wbuf_62 VSS=DVSS VDD=DVDD
XFE_PHC543_n_89 DEL1 $PINS I=n_89 Z=FE_PHN543_n_89 VSS=DVSS VDD=DVDD
XFE_PHC542_n_73 DEL1 $PINS I=n_73 Z=FE_PHN542_n_73 VSS=DVSS VDD=DVDD
XFE_PHC541_n_72 DEL1 $PINS I=n_72 Z=FE_PHN541_n_72 VSS=DVSS VDD=DVDD
XFE_PHC540_n_71 DEL1 $PINS I=n_71 Z=FE_PHN540_n_71 VSS=DVSS VDD=DVDD
XFE_PHC539_n_87 DEL1 $PINS I=n_87 Z=FE_PHN539_n_87 VSS=DVSS VDD=DVDD
XFE_PHC538_n_90 DEL1 $PINS I=FE_PHN621_n_90 Z=FE_PHN538_n_90 VSS=DVSS VDD=DVDD
XFE_PHC537_n_93 DEL1 $PINS I=n_93 Z=FE_PHN537_n_93 VSS=DVSS VDD=DVDD
XFE_PHC536_n_88 DEL1 $PINS I=n_88 Z=FE_PHN536_n_88 VSS=DVSS VDD=DVDD
XFE_PHC535_n_92 DEL1 $PINS I=n_92 Z=FE_PHN535_n_92 VSS=DVSS VDD=DVDD
XFE_PHC534_n_91 DEL1 $PINS I=n_91 Z=FE_PHN534_n_91 VSS=DVSS VDD=DVDD
XFE_PHC533_n_81 DEL1 $PINS I=FE_PHN533_n_81 Z=n_81 VSS=DVSS VDD=DVDD
XFE_PHC532_n_82 DEL1 $PINS I=FE_PHN532_n_82 Z=n_82 VSS=DVSS VDD=DVDD
XFE_PHC531_n_80 DEL1 $PINS I=FE_PHN531_n_80 Z=n_80 VSS=DVSS VDD=DVDD
XFE_PHC530_sram_addr_6 DEL015 $PINS I=FE_PHN530_sram_addr_6
+ Z=FE_PHN357_sram_addr_6 VSS=DVSS VDD=DVDD
XFE_PHC529_n_28 DEL1 $PINS I=n_28 Z=FE_PHN529_n_28 VSS=DVSS VDD=DVDD
XFE_PHC528_n_32 DEL1 $PINS I=FE_PDN3_n_32 Z=FE_PHN528_n_32 VSS=DVSS VDD=DVDD
XFE_PHC527_n_30 DEL1 $PINS I=FE_PHN527_n_30 Z=n_30 VSS=DVSS VDD=DVDD
XFE_PHC526_n_34 DEL1 $PINS I=FE_PDN690_n_34 Z=FE_PHN526_n_34 VSS=DVSS VDD=DVDD
XFE_PHC525_n_31 DEL1 $PINS I=n_31 Z=FE_PHN525_n_31 VSS=DVSS VDD=DVDD
XFE_PHC524_n_54 DEL1 $PINS I=n_54 Z=FE_PHN524_n_54 VSS=DVSS VDD=DVDD
XFE_PHC523_n_61 DEL1 $PINS I=n_61 Z=FE_PHN523_n_61 VSS=DVSS VDD=DVDD
XFE_PHC522_n_57 DEL1 $PINS I=FE_PHN522_n_57 Z=n_57 VSS=DVSS VDD=DVDD
XFE_PHC521_n_62 DEL1 $PINS I=n_62 Z=FE_PHN521_n_62 VSS=DVSS VDD=DVDD
XFE_PHC520_n_56 DEL1 $PINS I=FE_PHN520_n_56 Z=n_56 VSS=DVSS VDD=DVDD
XFE_PHC519_n_60 DEL1 $PINS I=FE_PHN519_n_60 Z=n_60 VSS=DVSS VDD=DVDD
XFE_PHC518_n_53 DEL1 $PINS I=n_53 Z=FE_PHN518_n_53 VSS=DVSS VDD=DVDD
XFE_PHC517_n_96 DEL1 $PINS I=n_96 Z=FE_PHN517_n_96 VSS=DVSS VDD=DVDD
XFE_PHC516_n_18 DEL1 $PINS I=FE_PHN516_n_18 Z=n_18 VSS=DVSS VDD=DVDD
XFE_PHC515_n_17 DEL1 $PINS I=n_17 Z=FE_PHN515_n_17 VSS=DVSS VDD=DVDD
XFE_PHC514_n_45 DEL1 $PINS I=n_45 Z=FE_PHN514_n_45 VSS=DVSS VDD=DVDD
XFE_PHC513_n_46 DEL1 $PINS I=n_46 Z=FE_PHN513_n_46 VSS=DVSS VDD=DVDD
XFE_PHC512_bus_addr_8 CKBD0 $PINS I=FE_PHN160_bus_addr_8 Z=FE_PHN512_bus_addr_8
+ VSS=DVSS VDD=DVDD
XFE_PHC511_n_97 DEL01 $PINS I=FE_PHN511_n_97 Z=n_97 VSS=DVSS VDD=DVDD
XFE_PHC510_rstn CKBD0 $PINS I=FE_PHN610_rstn Z=FE_PHN510_rstn VSS=DVSS VDD=DVDD
XFE_PHC509_bus_addr_2 DEL01 $PINS I=FE_PHN151_bus_addr_2 Z=FE_PHN509_bus_addr_2
+ VSS=DVSS VDD=DVDD
XFE_PHC508_sram_addr_5 DEL015 $PINS I=FE_PHN368_sram_addr_5
+ Z=FE_PHN508_sram_addr_5 VSS=DVSS VDD=DVDD
XFE_PHC507_n_12 DEL1 $PINS I=FE_PHN507_n_12 Z=n_12 VSS=DVSS VDD=DVDD
XFE_PHC506_tpu_dout_44 CKBD1 $PINS I=FE_PHN108_tpu_dout_44
+ Z=FE_PHN506_tpu_dout_44 VSS=DVSS VDD=DVDD
XFE_PHC505_tpu_dout_43 CKBD1 $PINS I=FE_PHN60_tpu_dout_43
+ Z=FE_PHN505_tpu_dout_43 VSS=DVSS VDD=DVDD
XFE_PHC504_tpu_dout_15 BUFFD1 $PINS I=FE_PHN254_tpu_dout_15
+ Z=FE_PHN504_tpu_dout_15 VSS=DVSS VDD=DVDD
XFE_PHC503_tpu_dout_42 CKBD1 $PINS I=FE_PHN106_tpu_dout_42
+ Z=FE_PHN503_tpu_dout_42 VSS=DVSS VDD=DVDD
XFE_PHC502_tpu_dout_53 BUFFD1 $PINS I=FE_PHN34_tpu_dout_53
+ Z=FE_PHN502_tpu_dout_53 VSS=DVSS VDD=DVDD
XFE_PHC501_tpu_dout_45 CKBD1 $PINS I=FE_PHN62_tpu_dout_45
+ Z=FE_PHN501_tpu_dout_45 VSS=DVSS VDD=DVDD
XFE_PHC500_tpu_dout_19 CKBD1 $PINS I=FE_PHN94_tpu_dout_19
+ Z=FE_PHN500_tpu_dout_19 VSS=DVSS VDD=DVDD
XFE_PHC499_tpu_dout_3 CKBD1 $PINS I=FE_PHN122_tpu_dout_3 Z=FE_PHN499_tpu_dout_3
+ VSS=DVSS VDD=DVDD
XFE_PHC498_tpu_dout_18 CKBD1 $PINS I=FE_PHN116_tpu_dout_18
+ Z=FE_PHN498_tpu_dout_18 VSS=DVSS VDD=DVDD
XFE_PHC497_bus_wbuf_16 CKBD0 $PINS I=FE_PHN575_bus_wbuf_16
+ Z=FE_PHN497_bus_wbuf_16 VSS=DVSS VDD=DVDD
XFE_PHC496_tpu_dout_27 CKBD1 $PINS I=FE_PHN130_tpu_dout_27
+ Z=FE_PHN496_tpu_dout_27 VSS=DVSS VDD=DVDD
XFE_PHC495_tpu_dout_16 CKBD1 $PINS I=FE_PHN52_tpu_dout_16
+ Z=FE_PHN495_tpu_dout_16 VSS=DVSS VDD=DVDD
XFE_PHC494_tpu_dout_41 CKBD1 $PINS I=FE_PHN80_tpu_dout_41
+ Z=FE_PHN494_tpu_dout_41 VSS=DVSS VDD=DVDD
XFE_PHC493_tpu_dout_25 CKBD1 $PINS I=FE_PHN132_tpu_dout_25
+ Z=FE_PHN493_tpu_dout_25 VSS=DVSS VDD=DVDD
XFE_PHC492_tpu_dout_33 CKBD1 $PINS I=FE_PHN124_tpu_dout_33
+ Z=FE_PHN492_tpu_dout_33 VSS=DVSS VDD=DVDD
XFE_PHC491_tpu_dout_49 CKBD1 $PINS I=FE_PHN40_tpu_dout_49
+ Z=FE_PHN491_tpu_dout_49 VSS=DVSS VDD=DVDD
XFE_PHC490_tpu_dout_6 BUFFD1 $PINS I=FE_PHN120_tpu_dout_6
+ Z=FE_PHN490_tpu_dout_6 VSS=DVSS VDD=DVDD
XFE_PHC489_tpu_dout_17 CKBD1 $PINS I=FE_PHN118_tpu_dout_17
+ Z=FE_PHN489_tpu_dout_17 VSS=DVSS VDD=DVDD
XFE_PHC488_tpu_dout_0 CKBD1 $PINS I=FE_PHN102_tpu_dout_0 Z=FE_PHN488_tpu_dout_0
+ VSS=DVSS VDD=DVDD
XFE_PHC487_tpu_dout_46 BUFFD1 $PINS I=FE_PHN110_tpu_dout_46
+ Z=FE_PHN487_tpu_dout_46 VSS=DVSS VDD=DVDD
XFE_PHC486_tpu_dout_28 CKBD1 $PINS I=FE_PHN136_tpu_dout_28
+ Z=FE_PHN486_tpu_dout_28 VSS=DVSS VDD=DVDD
XFE_PHC485_tpu_dout_24 CKBD1 $PINS I=FE_PHN140_tpu_dout_24
+ Z=FE_PHN485_tpu_dout_24 VSS=DVSS VDD=DVDD
XFE_PHC484_tpu_dout_23 BUFFD1 $PINS I=FE_PHN242_tpu_dout_23
+ Z=FE_PHN484_tpu_dout_23 VSS=DVSS VDD=DVDD
XFE_PHC483_tpu_dout_2 CKBD1 $PINS I=FE_PHN56_tpu_dout_2 Z=FE_PHN483_tpu_dout_2
+ VSS=DVSS VDD=DVDD
XFE_PHC482_tpu_dout_1 BUFFD1 $PINS I=FE_PHN88_tpu_dout_1 Z=FE_PHN482_tpu_dout_1
+ VSS=DVSS VDD=DVDD
XFE_PHC481_tpu_dout_35 CKBD1 $PINS I=FE_PHN70_tpu_dout_35
+ Z=FE_PHN481_tpu_dout_35 VSS=DVSS VDD=DVDD
XFE_PHC480_tpu_dout_32 BUFFD1 $PINS I=FE_PHN72_tpu_dout_32
+ Z=FE_PHN480_tpu_dout_32 VSS=DVSS VDD=DVDD
XFE_PHC479_bus_wbuf_14 DEL005 $PINS I=bus_wbuf<14> Z=FE_PHN479_bus_wbuf_14
+ VSS=DVSS VDD=DVDD
XFE_PHC478_tpu_dout_34 CKBD1 $PINS I=FE_PHN90_tpu_dout_34
+ Z=FE_PHN478_tpu_dout_34 VSS=DVSS VDD=DVDD
XFE_PHC477_tpu_dout_30 CKBD1 $PINS I=FE_PHN144_tpu_dout_30
+ Z=FE_PHN477_tpu_dout_30 VSS=DVSS VDD=DVDD
XFE_PHC476_tpu_dout_8 BUFFD1 $PINS I=FE_PHN86_tpu_dout_8 Z=FE_PHN476_tpu_dout_8
+ VSS=DVSS VDD=DVDD
XFE_PHC475_tpu_dout_10 CKBD1 $PINS I=FE_PHN84_tpu_dout_10
+ Z=FE_PHN475_tpu_dout_10 VSS=DVSS VDD=DVDD
XFE_PHC474_tpu_dout_7 DEL005 $PINS I=FE_PHN58_tpu_dout_7 Z=FE_PHN474_tpu_dout_7
+ VSS=DVSS VDD=DVDD
XFE_PHC473_tpu_dout_9 CKBD1 $PINS I=FE_PHN100_tpu_dout_9 Z=FE_PHN473_tpu_dout_9
+ VSS=DVSS VDD=DVDD
XFE_PHC472_tpu_dout_20 BUFFD1 $PINS I=FE_PHN146_tpu_dout_20
+ Z=FE_PHN472_tpu_dout_20 VSS=DVSS VDD=DVDD
XFE_PHC471_tpu_dout_29 CKBD1 $PINS I=FE_PHN148_tpu_dout_29
+ Z=FE_PHN471_tpu_dout_29 VSS=DVSS VDD=DVDD
XFE_PHC470_bus_wbuf_10 CKBD0 $PINS I=FE_PHN470_bus_wbuf_10 Z=bus_wbuf<10>
+ VSS=DVSS VDD=DVDD
XFE_PHC469_tpu_dout_5 CKBD1 $PINS I=FE_PHN138_tpu_dout_5 Z=FE_PHN469_tpu_dout_5
+ VSS=DVSS VDD=DVDD
XFE_PHC468_tpu_dout_26 CKBD1 $PINS I=FE_PHN142_tpu_dout_26
+ Z=FE_PHN468_tpu_dout_26 VSS=DVSS VDD=DVDD
XFE_PHC467_bus_wbuf_6 DEL015 $PINS I=bus_wbuf<6> Z=FE_PHN467_bus_wbuf_6
+ VSS=DVSS VDD=DVDD
XFE_PHC466_tpu_dout_52 BUFFD1 $PINS I=FE_PHN38_tpu_dout_52
+ Z=FE_PHN466_tpu_dout_52 VSS=DVSS VDD=DVDD
XFE_PHC465_bus_wbuf_2 DEL015 $PINS I=FE_PDN691_bus_wbuf_2
+ Z=FE_PHN465_bus_wbuf_2 VSS=DVSS VDD=DVDD
XFE_PHC464_tpu_dout_48 BUFFD1 $PINS I=FE_PHN42_tpu_dout_48
+ Z=FE_PHN464_tpu_dout_48 VSS=DVSS VDD=DVDD
XFE_PHC463_bus_wbuf_26 DEL005 $PINS I=bus_wbuf<26> Z=FE_PHN463_bus_wbuf_26
+ VSS=DVSS VDD=DVDD
XFE_PHC462_bus_wbuf_4 DEL015 $PINS I=bus_wbuf<4> Z=FE_PHN462_bus_wbuf_4
+ VSS=DVSS VDD=DVDD
XFE_PHC461_tpu_dout_4 BUFFD1 $PINS I=FE_PHN104_tpu_dout_4
+ Z=FE_PHN461_tpu_dout_4 VSS=DVSS VDD=DVDD
XFE_PHC460_bus_wbuf_0 DEL015 $PINS I=bus_wbuf<0> Z=FE_PHN460_bus_wbuf_0
+ VSS=DVSS VDD=DVDD
XFE_PHC459_bus_wbuf_50 DEL01 $PINS I=FE_PHN459_bus_wbuf_50
+ Z=FE_PHN194_bus_wbuf_50 VSS=DVSS VDD=DVDD
XFE_PHC458_tpu_dout_54 BUFFD1 $PINS I=FE_PHN46_tpu_dout_54
+ Z=FE_PHN458_tpu_dout_54 VSS=DVSS VDD=DVDD
XFE_PHC457_tpu_dout_57 CKBD0 $PINS I=FE_PHN30_tpu_dout_57
+ Z=FE_PHN457_tpu_dout_57 VSS=DVSS VDD=DVDD
XFE_PHC456_tpu_dout_55 CKBD0 $PINS I=FE_PHN66_tpu_dout_55
+ Z=FE_PHN456_tpu_dout_55 VSS=DVSS VDD=DVDD
XFE_PHC455_bus_wbuf_44 DEL015 $PINS I=FE_PHN455_bus_wbuf_44 Z=bus_wbuf<44>
+ VSS=DVSS VDD=DVDD
XFE_PHC454_bus_wbuf_52 DEL0 $PINS I=bus_wbuf<52> Z=FE_PHN454_bus_wbuf_52
+ VSS=DVSS VDD=DVDD
XFE_PHC453_bus_wbuf_40 DEL01 $PINS I=bus_wbuf<40> Z=FE_PHN453_bus_wbuf_40
+ VSS=DVSS VDD=DVDD
XFE_PHC452_tpu_dout_51 CKBD0 $PINS I=FE_PHN64_tpu_dout_51
+ Z=FE_PHN452_tpu_dout_51 VSS=DVSS VDD=DVDD
XFE_PHC451_tpu_dout_58 BUFFD1 $PINS I=FE_PHN68_tpu_dout_58
+ Z=FE_PHN451_tpu_dout_58 VSS=DVSS VDD=DVDD
XFE_PHC450_tpu_dout_62 BUFFD1 $PINS I=FE_PHN28_tpu_dout_62
+ Z=FE_PHN450_tpu_dout_62 VSS=DVSS VDD=DVDD
XFE_PHC449_bus_wbuf_46 DEL01 $PINS I=FE_PHN449_bus_wbuf_46 Z=bus_wbuf<46>
+ VSS=DVSS VDD=DVDD
XFE_PHC448_bus_wbuf_24 DEL01 $PINS I=bus_wbuf<24> Z=FE_PHN448_bus_wbuf_24
+ VSS=DVSS VDD=DVDD
XFE_PHC447_sram_addr_8 DEL01 $PINS I=FE_PHN315_sram_addr_8
+ Z=FE_PHN447_sram_addr_8 VSS=DVSS VDD=DVDD
XFE_PHC446_bus_wbuf_21 DEL01 $PINS I=FE_PHN446_bus_wbuf_21 Z=bus_wbuf<21>
+ VSS=DVSS VDD=DVDD
XFE_PHC445_bus_wbuf_22 DEL01 $PINS I=FE_PHN445_bus_wbuf_22 Z=bus_wbuf<22>
+ VSS=DVSS VDD=DVDD
XFE_PHC444_bus_wbuf_12 CKBD1 $PINS I=FE_PHN444_bus_wbuf_12 Z=bus_wbuf<12>
+ VSS=DVSS VDD=DVDD
XFE_PHC443_tpu_dout_61 CKBD0 $PINS I=FE_PHN48_tpu_dout_61
+ Z=FE_PHN443_tpu_dout_61 VSS=DVSS VDD=DVDD
XFE_PHC442_bus_wbuf_53 DEL01 $PINS I=bus_wbuf<53> Z=FE_PHN442_bus_wbuf_53
+ VSS=DVSS VDD=DVDD
XFE_PHC441_bus_wbuf_49 DEL01 $PINS I=FE_PHN441_bus_wbuf_49 Z=bus_wbuf<49>
+ VSS=DVSS VDD=DVDD
XFE_PHC440_tpu_dout_63 BUFFD1 $PINS I=FE_PHN26_tpu_dout_63
+ Z=FE_PHN440_tpu_dout_63 VSS=DVSS VDD=DVDD
XFE_PHC439_bus_wbuf_13 CKBD1 $PINS I=FE_PHN439_bus_wbuf_13 Z=bus_wbuf<13>
+ VSS=DVSS VDD=DVDD
XFE_PHC438_bus_wbuf_11 DEL005 $PINS I=FE_PHN438_bus_wbuf_11 Z=bus_wbuf<11>
+ VSS=DVSS VDD=DVDD
XFE_PHC437_tpu_dout_59 BUFFD1 $PINS I=FE_PHN24_tpu_dout_59
+ Z=FE_PHN437_tpu_dout_59 VSS=DVSS VDD=DVDD
XFE_PHC436_tpu_dout_50 CKBD0 $PINS I=FE_PHN44_tpu_dout_50
+ Z=FE_PHN436_tpu_dout_50 VSS=DVSS VDD=DVDD
XFE_PHC435_tpu_dout_60 CKBD0 $PINS I=FE_PHN50_tpu_dout_60
+ Z=FE_PHN435_tpu_dout_60 VSS=DVSS VDD=DVDD
XFE_PHC434_bus_wbuf_54 DEL01 $PINS I=bus_wbuf<54> Z=FE_PHN434_bus_wbuf_54
+ VSS=DVSS VDD=DVDD
XFE_PHC433_tpu_dout_47 CKBD0 $PINS I=FE_PHN36_tpu_dout_47
+ Z=FE_PHN433_tpu_dout_47 VSS=DVSS VDD=DVDD
XFE_PHC432_bus_wbuf_20 DEL01 $PINS I=bus_wbuf<20> Z=FE_PHN432_bus_wbuf_20
+ VSS=DVSS VDD=DVDD
XFE_PHC431_bus_wbuf_23 DEL01 $PINS I=bus_wbuf<23> Z=FE_PHN431_bus_wbuf_23
+ VSS=DVSS VDD=DVDD
XFE_PHC430_bus_wbuf_55 DEL01 $PINS I=bus_wbuf<55> Z=FE_PHN430_bus_wbuf_55
+ VSS=DVSS VDD=DVDD
XFE_PHC429_bus_wbuf_27 DEL01 $PINS I=FE_PHN429_bus_wbuf_27 Z=bus_wbuf<27>
+ VSS=DVSS VDD=DVDD
XFE_PHC428_bus_wbuf_43 DEL01 $PINS I=FE_PHN428_bus_wbuf_43 Z=bus_wbuf<43>
+ VSS=DVSS VDD=DVDD
XFE_PHC427_bus_wbuf_42 DEL01 $PINS I=FE_PHN427_bus_wbuf_42 Z=bus_wbuf<42>
+ VSS=DVSS VDD=DVDD
XFE_PHC426_bus_wbuf_41 DEL01 $PINS I=bus_wbuf<41> Z=FE_PHN426_bus_wbuf_41
+ VSS=DVSS VDD=DVDD
XFE_PHC425_bus_wbuf_45 DEL01 $PINS I=FE_PHN425_bus_wbuf_45 Z=bus_wbuf<45>
+ VSS=DVSS VDD=DVDD
XFE_PHC424_bus_wbuf_31 DEL015 $PINS I=FE_PHN424_bus_wbuf_31 Z=bus_wbuf<31>
+ VSS=DVSS VDD=DVDD
XFE_PHC423_bus_wbuf_38 DEL01 $PINS I=bus_wbuf<38> Z=FE_PHN423_bus_wbuf_38
+ VSS=DVSS VDD=DVDD
XFE_PHC422_bus_wbuf_28 DEL01 $PINS I=FE_PHN422_bus_wbuf_28 Z=bus_wbuf<28>
+ VSS=DVSS VDD=DVDD
XFE_PHC421_bus_wbuf_39 DEL01 $PINS I=bus_wbuf<39> Z=FE_PHN421_bus_wbuf_39
+ VSS=DVSS VDD=DVDD
XFE_PHC420_bus_wbuf_33 DEL01 $PINS I=bus_wbuf<33> Z=FE_PHN420_bus_wbuf_33
+ VSS=DVSS VDD=DVDD
XFE_PHC419_bus_wbuf_37 DEL01 $PINS I=bus_wbuf<37> Z=FE_PHN419_bus_wbuf_37
+ VSS=DVSS VDD=DVDD
XFE_PHC418_bus_wbuf_47 DEL01 $PINS I=bus_wbuf<47> Z=FE_PHN418_bus_wbuf_47
+ VSS=DVSS VDD=DVDD
XFE_PHC417_bus_wbuf_29 DEL01 $PINS I=bus_wbuf<29> Z=FE_PHN417_bus_wbuf_29
+ VSS=DVSS VDD=DVDD
XFE_PHC416_bus_wbuf_19 DEL01 $PINS I=FE_PHN416_bus_wbuf_19 Z=bus_wbuf<19>
+ VSS=DVSS VDD=DVDD
XFE_PHC415_bus_wbuf_30 DEL01 $PINS I=FE_PHN415_bus_wbuf_30 Z=bus_wbuf<30>
+ VSS=DVSS VDD=DVDD
XFE_PHC414_bus_wbuf_32 DEL01 $PINS I=FE_PHN414_bus_wbuf_32 Z=bus_wbuf<32>
+ VSS=DVSS VDD=DVDD
XFE_PHC413_bus_wbuf_17 DEL005 $PINS I=FE_PHN413_bus_wbuf_17 Z=bus_wbuf<17>
+ VSS=DVSS VDD=DVDD
XFE_PHC412_bus_wbuf_18 DEL005 $PINS I=bus_wbuf<18> Z=FE_PHN412_bus_wbuf_18
+ VSS=DVSS VDD=DVDD
XFE_PHC411_bus_wbuf_34 DEL01 $PINS I=FE_PHN411_bus_wbuf_34 Z=bus_wbuf<34>
+ VSS=DVSS VDD=DVDD
XFE_PHC410_bus_wbuf_36 DEL01 $PINS I=FE_PHN410_bus_wbuf_36 Z=bus_wbuf<36>
+ VSS=DVSS VDD=DVDD
XFE_PHC409_bus_wbuf_35 DEL01 $PINS I=bus_wbuf<35> Z=FE_PHN409_bus_wbuf_35
+ VSS=DVSS VDD=DVDD
XFE_PHC408_bus_wbuf_25 CKBD0 $PINS I=FE_PHN408_bus_wbuf_25 Z=bus_wbuf<25>
+ VSS=DVSS VDD=DVDD
XFE_PHC407_sram_addr_7 DEL015 $PINS I=FE_PHN407_sram_addr_7
+ Z=FE_PHN314_sram_addr_7 VSS=DVSS VDD=DVDD
XFE_PHC406_bus_wbuf_48 DEL01 $PINS I=FE_PHN406_bus_wbuf_48 Z=bus_wbuf<48>
+ VSS=DVSS VDD=DVDD
XFE_PHC405_bus_din_0 CKBD1 $PINS I=FE_PHN12_bus_din_0 Z=FE_PHN617_bus_din_0
+ VSS=DVSS VDD=DVDD
XFE_PHC404_bus_wbuf_7 DEL015 $PINS I=bus_wbuf<7> Z=FE_PHN404_bus_wbuf_7
+ VSS=DVSS VDD=DVDD
XFE_PHC403_bus_we BUFFD2 $PINS I=FE_PHN403_bus_we Z=FE_PHN3_bus_we VSS=DVSS
+ VDD=DVDD
XFE_PHC402_bus_wbuf_5 DEL015 $PINS I=bus_wbuf<5> Z=FE_PHN402_bus_wbuf_5
+ VSS=DVSS VDD=DVDD
XFE_PHC401_bus_wbuf_3 DEL015 $PINS I=bus_wbuf<3> Z=FE_PHN401_bus_wbuf_3
+ VSS=DVSS VDD=DVDD
XFE_PHC400_bus_wbuf_57 DEL015 $PINS I=FE_PHN400_bus_wbuf_57 Z=bus_wbuf<57>
+ VSS=DVSS VDD=DVDD
XFE_PHC399_bus_wbuf_56 DEL015 $PINS I=FE_PHN399_bus_wbuf_56 Z=bus_wbuf<56>
+ VSS=DVSS VDD=DVDD
XFE_PHC398_sram_wen DEL1 $PINS I=FE_PHN398_sram_wen Z=FE_PHN607_sram_wen
+ VSS=DVSS VDD=DVDD
XFE_PDC397_tpu_dout_56 CKBD12 $PINS I=FE_PDN396_tpu_dout_56 Z=tpu_dout<56>
+ VSS=DVSS VDD=DVDD
XFE_PHC395_bus_addr_10 DEL015 $PINS I=FE_PHN238_bus_addr_10
+ Z=FE_PHN395_bus_addr_10 VSS=DVSS VDD=DVDD
XFE_PHC394_tpu_dout_31 DEL0 $PINS I=FE_PHN377_tpu_dout_31
+ Z=FE_PHN394_tpu_dout_31 VSS=DVSS VDD=DVDD
XFE_PHC393_tpu_dout_11 DEL0 $PINS I=FE_PHN379_tpu_dout_11
+ Z=FE_PHN393_tpu_dout_11 VSS=DVSS VDD=DVDD
XFE_PHC392_tpu_dout_12 DEL0 $PINS I=FE_PHN381_tpu_dout_12
+ Z=FE_PHN392_tpu_dout_12 VSS=DVSS VDD=DVDD
XFE_PHC391_tpu_dout_13 DEL0 $PINS I=FE_PHN383_tpu_dout_13
+ Z=FE_PHN391_tpu_dout_13 VSS=DVSS VDD=DVDD
XFE_PHC390_tpu_dout_14 DEL0 $PINS I=FE_PHN385_tpu_dout_14
+ Z=FE_PHN390_tpu_dout_14 VSS=DVSS VDD=DVDD
XFE_PHC389_bus_wbuf_8 BUFFD1 $PINS I=FE_PHN365_bus_wbuf_8
+ Z=FE_PHN389_bus_wbuf_8 VSS=DVSS VDD=DVDD
XFE_PHC388_bus_wbuf_19 BUFFD1 $PINS I=FE_PHN362_bus_wbuf_19
+ Z=FE_PHN388_bus_wbuf_19 VSS=DVSS VDD=DVDD
XFE_PHC387_bus_wbuf_9 BUFFD1 $PINS I=FE_PHN364_bus_wbuf_9
+ Z=FE_PHN387_bus_wbuf_9 VSS=DVSS VDD=DVDD
XFE_PHC386_tpu_dout_14 CKBD12 $PINS I=FE_PHN390_tpu_dout_14 Z=tpu_dout<14>
+ VSS=DVSS VDD=DVDD
XFE_PHC384_tpu_dout_13 CKBD12 $PINS I=FE_PHN391_tpu_dout_13 Z=tpu_dout<13>
+ VSS=DVSS VDD=DVDD
XFE_PHC382_tpu_dout_12 CKBD12 $PINS I=FE_PHN392_tpu_dout_12 Z=tpu_dout<12>
+ VSS=DVSS VDD=DVDD
XFE_PHC380_tpu_dout_11 CKBD12 $PINS I=FE_PHN393_tpu_dout_11 Z=tpu_dout<11>
+ VSS=DVSS VDD=DVDD
XFE_PHC378_tpu_dout_31 BUFFD8 $PINS I=FE_PHN394_tpu_dout_31 Z=tpu_dout<31>
+ VSS=DVSS VDD=DVDD
XFE_PHC376_sram_addr_8 BUFFD1 $PINS I=sram_addr<8> Z=FE_PHN376_sram_addr_8
+ VSS=DVSS VDD=DVDD
XFE_PHC375_bus_wbuf_15 CKBD1 $PINS I=FE_PHN309_bus_wbuf_15
+ Z=FE_PHN375_bus_wbuf_15 VSS=DVSS VDD=DVDD
XFE_PHC374_bus_wbuf_48 BUFFD1 $PINS I=FE_PHN366_bus_wbuf_48
+ Z=FE_PHN374_bus_wbuf_48 VSS=DVSS VDD=DVDD
XFE_PHC373_bus_addr_10 DEL0 $PINS I=bus_addr<10> Z=FE_PHN373_bus_addr_10
+ VSS=DVSS VDD=DVDD
XFE_PHC372_rstn DEL1 $PINS I=FE_PHN610_rstn Z=FE_PHN372_rstn VSS=DVSS VDD=DVDD
XFE_PHC371_bus_wbuf_62 BUFFD0 $PINS I=FE_PHN222_bus_wbuf_62
+ Z=FE_PHN544_bus_wbuf_62 VSS=DVSS VDD=DVDD
XFE_PHC370_bus_wbuf_61 BUFFD0 $PINS I=FE_PHN223_bus_wbuf_61
+ Z=FE_PHN370_bus_wbuf_61 VSS=DVSS VDD=DVDD
XFE_PHC369_bus_wbuf_60 BUFFD0 $PINS I=FE_PHN221_bus_wbuf_60
+ Z=FE_PHN554_bus_wbuf_60 VSS=DVSS VDD=DVDD
XFE_PHC368_sram_addr_5 BUFFD1 $PINS I=FE_PHN237_sram_addr_5
+ Z=FE_PHN368_sram_addr_5 VSS=DVSS VDD=DVDD
XFE_PHC367_bus_wbuf_1 BUFFD1 $PINS I=FE_PHN211_bus_wbuf_1
+ Z=FE_PHN548_bus_wbuf_1 VSS=DVSS VDD=DVDD
XFE_PHC366_bus_wbuf_48 CKBD0 $PINS I=FE_PHN210_bus_wbuf_48
+ Z=FE_PHN366_bus_wbuf_48 VSS=DVSS VDD=DVDD
XFE_PHC365_bus_wbuf_8 CKBD0 $PINS I=FE_PHN209_bus_wbuf_8 Z=FE_PHN365_bus_wbuf_8
+ VSS=DVSS VDD=DVDD
XFE_PHC364_bus_wbuf_9 CKBD0 $PINS I=FE_PHN205_bus_wbuf_9 Z=FE_PHN364_bus_wbuf_9
+ VSS=DVSS VDD=DVDD
XFE_PHC363_bus_wbuf_11 DEL01 $PINS I=FE_PHN206_bus_wbuf_11
+ Z=FE_PHN363_bus_wbuf_11 VSS=DVSS VDD=DVDD
XFE_PHC362_bus_wbuf_19 CKBD0 $PINS I=FE_PHN207_bus_wbuf_19
+ Z=FE_PHN362_bus_wbuf_19 VSS=DVSS VDD=DVDD
XFE_PHC361_bus_wbuf_13 DEL01 $PINS I=FE_PHN203_bus_wbuf_13
+ Z=FE_PHN361_bus_wbuf_13 VSS=DVSS VDD=DVDD
XFE_PHC360_bus_wbuf_54 DEL01 $PINS I=FE_PHN200_bus_wbuf_54
+ Z=FE_PHN360_bus_wbuf_54 VSS=DVSS VDD=DVDD
XFE_PHC359_bus_wbuf_12 DEL01 $PINS I=FE_PHN204_bus_wbuf_12
+ Z=FE_PHN359_bus_wbuf_12 VSS=DVSS VDD=DVDD
XFE_PHC358_bus_wbuf_18 DEL01 $PINS I=FE_PHN201_bus_wbuf_18
+ Z=FE_PHN358_bus_wbuf_18 VSS=DVSS VDD=DVDD
XFE_PHC357_sram_addr_6 CKBD0 $PINS I=FE_PHN236_sram_addr_6
+ Z=FE_PHN530_sram_addr_6 VSS=DVSS VDD=DVDD
XFE_PHC356_bus_wbuf_10 DEL01 $PINS I=FE_PHN199_bus_wbuf_10
+ Z=FE_PHN356_bus_wbuf_10 VSS=DVSS VDD=DVDD
XFE_PHC355_bus_wbuf_17 DEL01 $PINS I=FE_PHN198_bus_wbuf_17
+ Z=FE_PHN355_bus_wbuf_17 VSS=DVSS VDD=DVDD
XFE_PHC354_sram_addr_0 DEL01 $PINS I=FE_PHN233_sram_addr_0
+ Z=FE_PHN555_sram_addr_0 VSS=DVSS VDD=DVDD
XFE_PHC353_bus_wbuf_25 DEL01 $PINS I=FE_PHN179_bus_wbuf_25
+ Z=FE_PHN353_bus_wbuf_25 VSS=DVSS VDD=DVDD
XFE_PHC352_sram_addr_1 DEL01 $PINS I=FE_PHN230_sram_addr_1
+ Z=FE_PHN352_sram_addr_1 VSS=DVSS VDD=DVDD
XFE_PHC351_sram_addr_2 DEL01 $PINS I=FE_PHN232_sram_addr_2
+ Z=FE_PHN351_sram_addr_2 VSS=DVSS VDD=DVDD
XFE_PHC350_bus_wbuf_24 DEL01 $PINS I=FE_PHN186_bus_wbuf_24
+ Z=FE_PHN350_bus_wbuf_24 VSS=DVSS VDD=DVDD
XFE_PHC349_bus_wbuf_50 DEL01 $PINS I=FE_PHN194_bus_wbuf_50
+ Z=FE_PHN349_bus_wbuf_50 VSS=DVSS VDD=DVDD
XFE_PHC348_bus_wbuf_55 DEL01 $PINS I=FE_PHN196_bus_wbuf_55
+ Z=FE_PHN348_bus_wbuf_55 VSS=DVSS VDD=DVDD
XFE_PHC347_bus_wbuf_49 DEL01 $PINS I=FE_PHN193_bus_wbuf_49
+ Z=FE_PHN347_bus_wbuf_49 VSS=DVSS VDD=DVDD
XFE_PHC346_bus_wbuf_26 DEL01 $PINS I=FE_PHN182_bus_wbuf_26
+ Z=FE_PHN346_bus_wbuf_26 VSS=DVSS VDD=DVDD
XFE_PHC345_sram_addr_3 DEL01 $PINS I=FE_PHN231_sram_addr_3
+ Z=FE_PHN550_sram_addr_3 VSS=DVSS VDD=DVDD
XFE_PHC344_bus_wbuf_32 DEL01 $PINS I=FE_PHN195_bus_wbuf_32
+ Z=FE_PHN344_bus_wbuf_32 VSS=DVSS VDD=DVDD
XFE_PHC343_bus_wbuf_20 DEL01 $PINS I=FE_PHN192_bus_wbuf_20
+ Z=FE_PHN343_bus_wbuf_20 VSS=DVSS VDD=DVDD
XFE_PHC342_bus_wbuf_38 DEL01 $PINS I=FE_PHN189_bus_wbuf_38
+ Z=FE_PHN342_bus_wbuf_38 VSS=DVSS VDD=DVDD
XFE_PHC341_bus_wbuf_51 DEL02 $PINS I=FE_PHN190_bus_wbuf_51
+ Z=FE_PHN341_bus_wbuf_51 VSS=DVSS VDD=DVDD
XFE_PHC340_bus_wbuf_33 DEL01 $PINS I=FE_PHN188_bus_wbuf_33
+ Z=FE_PHN340_bus_wbuf_33 VSS=DVSS VDD=DVDD
XFE_PHC339_bus_wbuf_37 DEL01 $PINS I=FE_PHN191_bus_wbuf_37
+ Z=FE_PHN339_bus_wbuf_37 VSS=DVSS VDD=DVDD
XFE_PHC338_bus_wbuf_53 DEL01 $PINS I=FE_PHN183_bus_wbuf_53
+ Z=FE_PHN338_bus_wbuf_53 VSS=DVSS VDD=DVDD
XFE_PHC337_bus_wbuf_23 DEL01 $PINS I=FE_PHN185_bus_wbuf_23
+ Z=FE_PHN337_bus_wbuf_23 VSS=DVSS VDD=DVDD
XFE_PHC336_bus_wbuf_21 DEL01 $PINS I=FE_PHN187_bus_wbuf_21
+ Z=FE_PHN336_bus_wbuf_21 VSS=DVSS VDD=DVDD
XFE_PHC335_bus_wbuf_52 DEL01 $PINS I=FE_PHN180_bus_wbuf_52
+ Z=FE_PHN335_bus_wbuf_52 VSS=DVSS VDD=DVDD
XFE_PHC334_bus_wbuf_46 DEL01 $PINS I=FE_PHN178_bus_wbuf_46
+ Z=FE_PHN334_bus_wbuf_46 VSS=DVSS VDD=DVDD
XFE_PHC333_bus_wbuf_22 DEL01 $PINS I=FE_PHN184_bus_wbuf_22
+ Z=FE_PHN333_bus_wbuf_22 VSS=DVSS VDD=DVDD
XFE_PHC332_bus_wbuf_41 DEL01 $PINS I=FE_PHN176_bus_wbuf_41
+ Z=FE_PHN332_bus_wbuf_41 VSS=DVSS VDD=DVDD
XFE_PHC331_bus_wbuf_40 DEL01 $PINS I=FE_PHN177_bus_wbuf_40
+ Z=FE_PHN331_bus_wbuf_40 VSS=DVSS VDD=DVDD
XFE_PHC330_bus_wbuf_39 DEL01 $PINS I=FE_PHN181_bus_wbuf_39
+ Z=FE_PHN330_bus_wbuf_39 VSS=DVSS VDD=DVDD
XFE_PHC329_bus_wbuf_29 DEL01 $PINS I=FE_PHN175_bus_wbuf_29
+ Z=FE_PHN329_bus_wbuf_29 VSS=DVSS VDD=DVDD
XFE_PHC328_bus_wbuf_28 DEL01 $PINS I=FE_PHN165_bus_wbuf_28
+ Z=FE_PHN328_bus_wbuf_28 VSS=DVSS VDD=DVDD
XFE_PHC327_bus_wbuf_45 DEL01 $PINS I=FE_PHN171_bus_wbuf_45
+ Z=FE_PHN327_bus_wbuf_45 VSS=DVSS VDD=DVDD
XFE_PHC326_bus_wbuf_42 DEL01 $PINS I=FE_PHN174_bus_wbuf_42
+ Z=FE_PHN326_bus_wbuf_42 VSS=DVSS VDD=DVDD
XFE_PHC325_bus_wbuf_44 DEL01 $PINS I=FE_PHN167_bus_wbuf_44
+ Z=FE_PHN325_bus_wbuf_44 VSS=DVSS VDD=DVDD
XFE_PHC324_bus_wbuf_47 DEL01 $PINS I=FE_PHN169_bus_wbuf_47
+ Z=FE_PHN324_bus_wbuf_47 VSS=DVSS VDD=DVDD
XFE_PHC323_bus_wbuf_43 DEL01 $PINS I=FE_PHN166_bus_wbuf_43
+ Z=FE_PHN323_bus_wbuf_43 VSS=DVSS VDD=DVDD
XFE_PHC322_bus_wbuf_30 DEL01 $PINS I=FE_PHN172_bus_wbuf_30
+ Z=FE_PHN322_bus_wbuf_30 VSS=DVSS VDD=DVDD
XFE_PHC321_bus_wbuf_31 DEL01 $PINS I=FE_PHN170_bus_wbuf_31
+ Z=FE_PHN321_bus_wbuf_31 VSS=DVSS VDD=DVDD
XFE_PHC320_sram_addr_4 DEL01 $PINS I=FE_PHN229_sram_addr_4
+ Z=FE_PHN546_sram_addr_4 VSS=DVSS VDD=DVDD
XFE_PHC319_bus_wbuf_35 DEL01 $PINS I=FE_PHN168_bus_wbuf_35
+ Z=FE_PHN319_bus_wbuf_35 VSS=DVSS VDD=DVDD
XFE_PHC318_bus_wbuf_34 DEL01 $PINS I=FE_PHN173_bus_wbuf_34
+ Z=FE_PHN318_bus_wbuf_34 VSS=DVSS VDD=DVDD
XFE_PHC317_bus_wbuf_27 DEL01 $PINS I=FE_PHN164_bus_wbuf_27
+ Z=FE_PHN317_bus_wbuf_27 VSS=DVSS VDD=DVDD
XFE_PHC316_bus_wbuf_36 DEL01 $PINS I=FE_PHN161_bus_wbuf_36
+ Z=FE_PHN316_bus_wbuf_36 VSS=DVSS VDD=DVDD
XFE_PHC315_sram_addr_8 CKBD0 $PINS I=FE_PHN376_sram_addr_8
+ Z=FE_PHN315_sram_addr_8 VSS=DVSS VDD=DVDD
XFE_PHC314_sram_addr_7 DEL005 $PINS I=sram_addr<7> Z=FE_PHN407_sram_addr_7
+ VSS=DVSS VDD=DVDD
XFE_PHC313_tpu_dout_31 BUFFD8 $PINS I=FE_PHN312_tpu_dout_31
+ Z=FE_PHN377_tpu_dout_31 VSS=DVSS VDD=DVDD
XFE_PHC311_rstn DEL1 $PINS I=FE_PHN510_rstn Z=FE_PHN311_rstn VSS=DVSS VDD=DVDD
XFE_PHC310_sram_wen CKBD1 $PINS I=sram_wen Z=FE_PHN398_sram_wen VSS=DVSS
+ VDD=DVDD
XFE_PHC309_bus_wbuf_15 DEL005 $PINS I=bus_wbuf<15> Z=FE_PHN309_bus_wbuf_15
+ VSS=DVSS VDD=DVDD
XFE_PHC308_bus_wbuf_14 DEL01 $PINS I=FE_PHN479_bus_wbuf_14
+ Z=FE_PHN308_bus_wbuf_14 VSS=DVSS VDD=DVDD
XFE_PHC307_bus_wbuf_16 DEL01 $PINS I=FE_PHN497_bus_wbuf_16
+ Z=FE_PHN307_bus_wbuf_16 VSS=DVSS VDD=DVDD
XFE_PHC306_bus_addr_7 DEL015 $PINS I=FE_PHN561_bus_addr_7
+ Z=FE_PHN306_bus_addr_7 VSS=DVSS VDD=DVDD
XFE_PHC305_bus_addr_8 DEL015 $PINS I=bus_addr<8> Z=FE_PHN305_bus_addr_8
+ VSS=DVSS VDD=DVDD
XFE_PHC304_bus_addr_4 DEL015 $PINS I=FE_PHN562_bus_addr_4
+ Z=FE_PHN304_bus_addr_4 VSS=DVSS VDD=DVDD
XFE_PHC303_bus_addr_3 DEL015 $PINS I=FE_PHN569_bus_addr_3
+ Z=FE_PHN303_bus_addr_3 VSS=DVSS VDD=DVDD
XFE_PHC302_bus_addr_5 DEL015 $PINS I=FE_PHN565_bus_addr_5
+ Z=FE_PHN302_bus_addr_5 VSS=DVSS VDD=DVDD
XFE_PHC301_bus_addr_6 DEL015 $PINS I=FE_PHN567_bus_addr_6
+ Z=FE_PHN301_bus_addr_6 VSS=DVSS VDD=DVDD
XFE_PHC300_bus_addr_9 DEL015 $PINS I=FE_PHN566_bus_addr_9
+ Z=FE_PHN300_bus_addr_9 VSS=DVSS VDD=DVDD
XFE_PHC299_bus_addr_11 DEL015 $PINS I=FE_PHN568_bus_addr_11
+ Z=FE_PHN299_bus_addr_11 VSS=DVSS VDD=DVDD
XFE_PHC298_tpu_re DEL0 $PINS I=tpu_re Z=FE_PHN298_tpu_re VSS=DVSS VDD=DVDD
XFE_PHC297_tpu_dout_56 DEL0 $PINS I=FE_PHN22_tpu_dout_56
+ Z=FE_PHN297_tpu_dout_56 VSS=DVSS VDD=DVDD
XFE_PHC296_tpu_dout_54 DEL0 $PINS I=FE_PHN458_tpu_dout_54
+ Z=FE_PHN296_tpu_dout_54 VSS=DVSS VDD=DVDD
XFE_PHC295_tpu_dout_58 DEL0 $PINS I=FE_PHN451_tpu_dout_58
+ Z=FE_PHN295_tpu_dout_58 VSS=DVSS VDD=DVDD
XFE_PHC294_tpu_dout_57 DEL0 $PINS I=FE_PHN457_tpu_dout_57
+ Z=FE_PHN294_tpu_dout_57 VSS=DVSS VDD=DVDD
XFE_PHC293_tpu_dout_60 DEL0 $PINS I=FE_PHN435_tpu_dout_60
+ Z=FE_PHN293_tpu_dout_60 VSS=DVSS VDD=DVDD
XFE_PHC292_tpu_dout_61 DEL0 $PINS I=FE_PHN443_tpu_dout_61
+ Z=FE_PHN292_tpu_dout_61 VSS=DVSS VDD=DVDD
XFE_PHC291_tpu_dout_62 DEL0 $PINS I=FE_PHN450_tpu_dout_62
+ Z=FE_PHN291_tpu_dout_62 VSS=DVSS VDD=DVDD
XFE_PHC290_tpu_dout_63 DEL0 $PINS I=FE_PHN440_tpu_dout_63
+ Z=FE_PHN290_tpu_dout_63 VSS=DVSS VDD=DVDD
XFE_PHC289_tpu_dout_50 DEL0 $PINS I=FE_PHN436_tpu_dout_50
+ Z=FE_PHN289_tpu_dout_50 VSS=DVSS VDD=DVDD
XFE_PHC288_tpu_dout_55 DEL0 $PINS I=FE_PHN456_tpu_dout_55
+ Z=FE_PHN288_tpu_dout_55 VSS=DVSS VDD=DVDD
XFE_PHC287_tpu_dout_59 DEL0 $PINS I=FE_PHN437_tpu_dout_59
+ Z=FE_PHN287_tpu_dout_59 VSS=DVSS VDD=DVDD
XFE_PHC286_tpu_dout_5 DEL0 $PINS I=FE_PHN469_tpu_dout_5 Z=FE_PHN286_tpu_dout_5
+ VSS=DVSS VDD=DVDD
XFE_PHC285_tpu_dout_4 DEL0 $PINS I=FE_PHN461_tpu_dout_4 Z=FE_PHN285_tpu_dout_4
+ VSS=DVSS VDD=DVDD
XFE_PHC284_tpu_dout_52 DEL0 $PINS I=FE_PHN466_tpu_dout_52
+ Z=FE_PHN284_tpu_dout_52 VSS=DVSS VDD=DVDD
XFE_PHC283_tpu_dout_48 DEL0 $PINS I=FE_PHN464_tpu_dout_48
+ Z=FE_PHN283_tpu_dout_48 VSS=DVSS VDD=DVDD
XFE_PHC282_tpu_dout_51 DEL0 $PINS I=FE_PHN452_tpu_dout_51
+ Z=FE_PHN282_tpu_dout_51 VSS=DVSS VDD=DVDD
XFE_PHC281_tpu_dout_49 DEL0 $PINS I=FE_PHN491_tpu_dout_49
+ Z=FE_PHN281_tpu_dout_49 VSS=DVSS VDD=DVDD
XFE_PHC280_tpu_dout_7 DEL0 $PINS I=FE_PHN474_tpu_dout_7 Z=FE_PHN280_tpu_dout_7
+ VSS=DVSS VDD=DVDD
XFE_PHC279_tpu_dout_47 DEL0 $PINS I=FE_PHN433_tpu_dout_47
+ Z=FE_PHN279_tpu_dout_47 VSS=DVSS VDD=DVDD
XFE_PHC278_tpu_dout_53 DEL0 $PINS I=FE_PHN502_tpu_dout_53
+ Z=FE_PHN278_tpu_dout_53 VSS=DVSS VDD=DVDD
XFE_PHC277_tpu_dout_45 DEL0 $PINS I=FE_PHN501_tpu_dout_45
+ Z=FE_PHN277_tpu_dout_45 VSS=DVSS VDD=DVDD
XFE_PHC276_tpu_dout_39 DEL0 $PINS I=FE_PHN32_tpu_dout_39
+ Z=FE_PHN276_tpu_dout_39 VSS=DVSS VDD=DVDD
XFE_PHC275_tpu_dout_44 DEL0 $PINS I=FE_PHN506_tpu_dout_44
+ Z=FE_PHN275_tpu_dout_44 VSS=DVSS VDD=DVDD
XFE_PHC274_tpu_dout_46 DEL0 $PINS I=FE_PHN487_tpu_dout_46
+ Z=FE_PHN274_tpu_dout_46 VSS=DVSS VDD=DVDD
XFE_PHC273_tpu_dout_6 DEL0 $PINS I=FE_PHN490_tpu_dout_6 Z=FE_PHN273_tpu_dout_6
+ VSS=DVSS VDD=DVDD
XFE_PHC272_tpu_dout_2 DEL0 $PINS I=FE_PHN483_tpu_dout_2 Z=FE_PHN272_tpu_dout_2
+ VSS=DVSS VDD=DVDD
XFE_PHC271_tpu_dout_38 DEL0 $PINS I=FE_PHN78_tpu_dout_38
+ Z=FE_PHN271_tpu_dout_38 VSS=DVSS VDD=DVDD
XFE_PHC270_tpu_dout_40 DEL0 $PINS I=FE_PHN92_tpu_dout_40
+ Z=FE_PHN270_tpu_dout_40 VSS=DVSS VDD=DVDD
XFE_PHC269_tpu_dout_41 DEL0 $PINS I=FE_PHN494_tpu_dout_41
+ Z=FE_PHN269_tpu_dout_41 VSS=DVSS VDD=DVDD
XFE_PHC268_tpu_dout_42 DEL0 $PINS I=FE_PHN503_tpu_dout_42
+ Z=FE_PHN268_tpu_dout_42 VSS=DVSS VDD=DVDD
XFE_PHC267_tpu_dout_43 DEL0 $PINS I=FE_PHN505_tpu_dout_43
+ Z=FE_PHN267_tpu_dout_43 VSS=DVSS VDD=DVDD
XFE_PHC266_tpu_dout_1 DEL0 $PINS I=FE_PHN482_tpu_dout_1 Z=FE_PHN266_tpu_dout_1
+ VSS=DVSS VDD=DVDD
XFE_PHC265_tpu_dout_36 DEL0 $PINS I=FE_PHN76_tpu_dout_36
+ Z=FE_PHN265_tpu_dout_36 VSS=DVSS VDD=DVDD
XFE_PHC264_tpu_dout_37 DEL0 $PINS I=FE_PHN74_tpu_dout_37
+ Z=FE_PHN264_tpu_dout_37 VSS=DVSS VDD=DVDD
XFE_PHC263_tpu_dout_0 DEL0 $PINS I=FE_PHN488_tpu_dout_0 Z=FE_PHN263_tpu_dout_0
+ VSS=DVSS VDD=DVDD
XFE_PHC262_tpu_dout_19 DEL0 $PINS I=FE_PHN500_tpu_dout_19
+ Z=FE_PHN262_tpu_dout_19 VSS=DVSS VDD=DVDD
XFE_PHC261_tpu_dout_32 DEL0 $PINS I=FE_PHN480_tpu_dout_32
+ Z=FE_PHN261_tpu_dout_32 VSS=DVSS VDD=DVDD
XFE_PHC260_tpu_dout_34 DEL0 $PINS I=FE_PHN478_tpu_dout_34
+ Z=FE_PHN260_tpu_dout_34 VSS=DVSS VDD=DVDD
XFE_PHC259_tpu_dout_35 DEL0 $PINS I=FE_PHN481_tpu_dout_35
+ Z=FE_PHN259_tpu_dout_35 VSS=DVSS VDD=DVDD
XFE_PHC258_tpu_dout_3 DEL0 $PINS I=FE_PHN499_tpu_dout_3 Z=FE_PHN258_tpu_dout_3
+ VSS=DVSS VDD=DVDD
XFE_PHC257_tpu_dout_9 DEL0 $PINS I=FE_PHN473_tpu_dout_9 Z=FE_PHN257_tpu_dout_9
+ VSS=DVSS VDD=DVDD
XFE_PHC256_tpu_dout_10 DEL0 $PINS I=FE_PHN475_tpu_dout_10
+ Z=FE_PHN256_tpu_dout_10 VSS=DVSS VDD=DVDD
XFE_PHC255_tpu_dout_8 DEL0 $PINS I=FE_PHN476_tpu_dout_8 Z=FE_PHN255_tpu_dout_8
+ VSS=DVSS VDD=DVDD
XFE_PHC254_tpu_dout_15 DEL0 $PINS I=FE_PHN126_tpu_dout_15
+ Z=FE_PHN254_tpu_dout_15 VSS=DVSS VDD=DVDD
XFE_PHC253_tpu_dout_16 DEL0 $PINS I=FE_PHN495_tpu_dout_16
+ Z=FE_PHN253_tpu_dout_16 VSS=DVSS VDD=DVDD
XFE_PHC252_tpu_dout_33 DEL0 $PINS I=FE_PHN492_tpu_dout_33
+ Z=FE_PHN252_tpu_dout_33 VSS=DVSS VDD=DVDD
XFE_PHC251_tpu_dout_21 DEL0 $PINS I=FE_PHN134_tpu_dout_21
+ Z=FE_PHN251_tpu_dout_21 VSS=DVSS VDD=DVDD
XFE_PHC250_tpu_dout_18 DEL0 $PINS I=FE_PHN498_tpu_dout_18
+ Z=FE_PHN250_tpu_dout_18 VSS=DVSS VDD=DVDD
XFE_PHC249_tpu_dout_17 DEL0 $PINS I=FE_PHN489_tpu_dout_17
+ Z=FE_PHN249_tpu_dout_17 VSS=DVSS VDD=DVDD
XFE_PHC248_tpu_dout_22 DEL0 $PINS I=FE_PHN82_tpu_dout_22
+ Z=FE_PHN248_tpu_dout_22 VSS=DVSS VDD=DVDD
XFE_PHC247_tpu_dout_25 DEL0 $PINS I=FE_PHN493_tpu_dout_25
+ Z=FE_PHN247_tpu_dout_25 VSS=DVSS VDD=DVDD
XFE_PHC246_tpu_dout_28 DEL0 $PINS I=FE_PHN486_tpu_dout_28
+ Z=FE_PHN246_tpu_dout_28 VSS=DVSS VDD=DVDD
XFE_PHC245_tpu_dout_20 DEL0 $PINS I=FE_PHN472_tpu_dout_20
+ Z=FE_PHN245_tpu_dout_20 VSS=DVSS VDD=DVDD
XFE_PHC244_tpu_dout_27 DEL0 $PINS I=FE_PHN496_tpu_dout_27
+ Z=FE_PHN244_tpu_dout_27 VSS=DVSS VDD=DVDD
XFE_PHC243_tpu_dout_26 DEL0 $PINS I=FE_PHN468_tpu_dout_26
+ Z=FE_PHN243_tpu_dout_26 VSS=DVSS VDD=DVDD
XFE_PHC242_tpu_dout_23 DEL0 $PINS I=FE_PHN114_tpu_dout_23
+ Z=FE_PHN242_tpu_dout_23 VSS=DVSS VDD=DVDD
XFE_PHC241_tpu_dout_24 DEL0 $PINS I=FE_PHN485_tpu_dout_24
+ Z=FE_PHN241_tpu_dout_24 VSS=DVSS VDD=DVDD
XFE_PHC240_tpu_dout_29 DEL0 $PINS I=FE_PHN471_tpu_dout_29
+ Z=FE_PHN240_tpu_dout_29 VSS=DVSS VDD=DVDD
XFE_PHC239_tpu_dout_30 DEL0 $PINS I=FE_PHN477_tpu_dout_30
+ Z=FE_PHN239_tpu_dout_30 VSS=DVSS VDD=DVDD
XFE_PHC238_bus_addr_10 DEL0 $PINS I=FE_PHN373_bus_addr_10
+ Z=FE_PHN238_bus_addr_10 VSS=DVSS VDD=DVDD
XFE_PHC237_sram_addr_5 DEL1 $PINS I=sram_addr<5> Z=FE_PHN237_sram_addr_5
+ VSS=DVSS VDD=DVDD
XFE_PHC236_sram_addr_6 DEL1 $PINS I=sram_addr<6> Z=FE_PHN236_sram_addr_6
+ VSS=DVSS VDD=DVDD
XFE_PHC235_sram_addr_8 DEL1 $PINS I=FE_PHN447_sram_addr_8
+ Z=FE_PHN235_sram_addr_8 VSS=DVSS VDD=DVDD
XFE_PHC234_sram_addr_7 DEL1 $PINS I=FE_PHN314_sram_addr_7
+ Z=FE_PHN234_sram_addr_7 VSS=DVSS VDD=DVDD
XFE_PHC233_sram_addr_0 DEL1 $PINS I=sram_addr<0> Z=FE_PHN233_sram_addr_0
+ VSS=DVSS VDD=DVDD
XFE_PHC232_sram_addr_2 DEL1 $PINS I=sram_addr<2> Z=FE_PHN232_sram_addr_2
+ VSS=DVSS VDD=DVDD
XFE_PHC231_sram_addr_3 DEL1 $PINS I=sram_addr<3> Z=FE_PHN231_sram_addr_3
+ VSS=DVSS VDD=DVDD
XFE_PHC230_sram_addr_1 DEL1 $PINS I=sram_addr<1> Z=FE_PHN230_sram_addr_1
+ VSS=DVSS VDD=DVDD
XFE_PHC229_sram_addr_4 DEL1 $PINS I=sram_addr<4> Z=FE_PHN229_sram_addr_4
+ VSS=DVSS VDD=DVDD
XFE_PHC228_bus_wbuf_56 DEL1 $PINS I=bus_wbuf<56> Z=FE_PHN228_bus_wbuf_56
+ VSS=DVSS VDD=DVDD
XFE_PHC227_bus_wbuf_57 DEL1 $PINS I=bus_wbuf<57> Z=FE_PHN227_bus_wbuf_57
+ VSS=DVSS VDD=DVDD
XFE_PHC226_bus_wbuf_58 DEL1 $PINS I=bus_wbuf<58> Z=FE_PHN551_bus_wbuf_58
+ VSS=DVSS VDD=DVDD
XFE_PHC225_bus_wbuf_63 DEL1 $PINS I=bus_wbuf<63> Z=FE_PHN553_bus_wbuf_63
+ VSS=DVSS VDD=DVDD
XFE_PHC224_bus_wbuf_59 DEL1 $PINS I=bus_wbuf<59> Z=FE_PHN552_bus_wbuf_59
+ VSS=DVSS VDD=DVDD
XFE_PHC223_bus_wbuf_61 DEL1 $PINS I=bus_wbuf<61> Z=FE_PHN223_bus_wbuf_61
+ VSS=DVSS VDD=DVDD
XFE_PHC222_bus_wbuf_62 DEL1 $PINS I=bus_wbuf<62> Z=FE_PHN222_bus_wbuf_62
+ VSS=DVSS VDD=DVDD
XFE_PHC221_bus_wbuf_60 DEL1 $PINS I=bus_wbuf<60> Z=FE_PHN221_bus_wbuf_60
+ VSS=DVSS VDD=DVDD
XFE_PHC220_bus_wbuf_7 DEL1 $PINS I=FE_PHN404_bus_wbuf_7 Z=FE_PHN220_bus_wbuf_7
+ VSS=DVSS VDD=DVDD
XFE_PHC219_bus_wbuf_6 DEL1 $PINS I=FE_PHN467_bus_wbuf_6 Z=FE_PHN219_bus_wbuf_6
+ VSS=DVSS VDD=DVDD
XFE_PHC218_rstn CKBD2 $PINS I=FE_PHN372_rstn Z=FE_PHN218_rstn VSS=DVSS VDD=DVDD
XFE_PHC217_sram_cen DEL1 $PINS I=sram_cen Z=FE_PHN217_sram_cen VSS=DVSS
+ VDD=DVDD
XFE_PHC216_bus_wbuf_4 DEL1 $PINS I=FE_PHN462_bus_wbuf_4 Z=FE_PHN216_bus_wbuf_4
+ VSS=DVSS VDD=DVDD
XFE_PHC215_bus_wbuf_3 DEL1 $PINS I=FE_PHN401_bus_wbuf_3 Z=FE_PHN215_bus_wbuf_3
+ VSS=DVSS VDD=DVDD
XFE_PHC214_bus_wbuf_5 DEL1 $PINS I=FE_PHN402_bus_wbuf_5 Z=FE_PHN214_bus_wbuf_5
+ VSS=DVSS VDD=DVDD
XFE_PHC213_bus_wbuf_2 DEL1 $PINS I=FE_PHN465_bus_wbuf_2 Z=FE_PHN213_bus_wbuf_2
+ VSS=DVSS VDD=DVDD
XFE_PHC212_bus_wbuf_0 DEL1 $PINS I=FE_PHN460_bus_wbuf_0 Z=FE_PHN212_bus_wbuf_0
+ VSS=DVSS VDD=DVDD
XFE_PHC211_bus_wbuf_1 DEL1 $PINS I=FE_PHN560_bus_wbuf_1 Z=FE_PHN211_bus_wbuf_1
+ VSS=DVSS VDD=DVDD
XFE_PHC210_bus_wbuf_48 DEL1 $PINS I=bus_wbuf<48> Z=FE_PHN210_bus_wbuf_48
+ VSS=DVSS VDD=DVDD
XFE_PHC209_bus_wbuf_8 DEL1 $PINS I=FE_PHN580_bus_wbuf_8 Z=FE_PHN209_bus_wbuf_8
+ VSS=DVSS VDD=DVDD
XFE_PHC208_bus_wbuf_15 DEL1 $PINS I=FE_PHN588_bus_wbuf_15
+ Z=FE_PHN208_bus_wbuf_15 VSS=DVSS VDD=DVDD
XFE_PHC207_bus_wbuf_19 DEL1 $PINS I=bus_wbuf<19> Z=FE_PHN207_bus_wbuf_19
+ VSS=DVSS VDD=DVDD
XFE_PHC206_bus_wbuf_11 DEL1 $PINS I=bus_wbuf<11> Z=FE_PHN206_bus_wbuf_11
+ VSS=DVSS VDD=DVDD
XFE_PHC205_bus_wbuf_9 DEL1 $PINS I=bus_wbuf<9> Z=FE_PHN205_bus_wbuf_9 VSS=DVSS
+ VDD=DVDD
XFE_PHC204_bus_wbuf_12 DEL1 $PINS I=bus_wbuf<12> Z=FE_PHN204_bus_wbuf_12
+ VSS=DVSS VDD=DVDD
XFE_PHC203_bus_wbuf_13 DEL1 $PINS I=bus_wbuf<13> Z=FE_PHN203_bus_wbuf_13
+ VSS=DVSS VDD=DVDD
XFE_PHC202_bus_wbuf_14 DEL1 $PINS I=FE_PHN308_bus_wbuf_14
+ Z=FE_PHN202_bus_wbuf_14 VSS=DVSS VDD=DVDD
XFE_PHC201_bus_wbuf_18 DEL1 $PINS I=FE_PHN412_bus_wbuf_18
+ Z=FE_PHN201_bus_wbuf_18 VSS=DVSS VDD=DVDD
XFE_PHC200_bus_wbuf_54 DEL1 $PINS I=FE_PHN434_bus_wbuf_54
+ Z=FE_PHN200_bus_wbuf_54 VSS=DVSS VDD=DVDD
XFE_PHC199_bus_wbuf_10 DEL1 $PINS I=bus_wbuf<10> Z=FE_PHN199_bus_wbuf_10
+ VSS=DVSS VDD=DVDD
XFE_PHC198_bus_wbuf_17 DEL1 $PINS I=bus_wbuf<17> Z=FE_PHN198_bus_wbuf_17
+ VSS=DVSS VDD=DVDD
XFE_PHC197_bus_wbuf_16 DEL1 $PINS I=FE_PHN307_bus_wbuf_16
+ Z=FE_PHN197_bus_wbuf_16 VSS=DVSS VDD=DVDD
XFE_PHC196_bus_wbuf_55 DEL1 $PINS I=FE_PHN430_bus_wbuf_55
+ Z=FE_PHN196_bus_wbuf_55 VSS=DVSS VDD=DVDD
XFE_PHC195_bus_wbuf_32 DEL1 $PINS I=bus_wbuf<32> Z=FE_PHN195_bus_wbuf_32
+ VSS=DVSS VDD=DVDD
XFE_PHC194_bus_wbuf_50 DEL1 $PINS I=bus_wbuf<50> Z=FE_PHN459_bus_wbuf_50
+ VSS=DVSS VDD=DVDD
XFE_PHC193_bus_wbuf_49 DEL1 $PINS I=bus_wbuf<49> Z=FE_PHN193_bus_wbuf_49
+ VSS=DVSS VDD=DVDD
XFE_PHC192_bus_wbuf_20 DEL1 $PINS I=FE_PHN432_bus_wbuf_20
+ Z=FE_PHN192_bus_wbuf_20 VSS=DVSS VDD=DVDD
XFE_PHC191_bus_wbuf_37 DEL1 $PINS I=FE_PHN419_bus_wbuf_37
+ Z=FE_PHN191_bus_wbuf_37 VSS=DVSS VDD=DVDD
XFE_PHC190_bus_wbuf_51 DEL1 $PINS I=bus_wbuf<51> Z=FE_PHN190_bus_wbuf_51
+ VSS=DVSS VDD=DVDD
XFE_PHC189_bus_wbuf_38 DEL1 $PINS I=FE_PHN423_bus_wbuf_38
+ Z=FE_PHN189_bus_wbuf_38 VSS=DVSS VDD=DVDD
XFE_PHC188_bus_wbuf_33 DEL1 $PINS I=FE_PHN420_bus_wbuf_33
+ Z=FE_PHN188_bus_wbuf_33 VSS=DVSS VDD=DVDD
XFE_PHC187_bus_wbuf_21 DEL1 $PINS I=bus_wbuf<21> Z=FE_PHN187_bus_wbuf_21
+ VSS=DVSS VDD=DVDD
XFE_PHC186_bus_wbuf_24 DEL1 $PINS I=FE_PHN448_bus_wbuf_24
+ Z=FE_PHN186_bus_wbuf_24 VSS=DVSS VDD=DVDD
XFE_PHC185_bus_wbuf_23 DEL1 $PINS I=FE_PHN431_bus_wbuf_23
+ Z=FE_PHN185_bus_wbuf_23 VSS=DVSS VDD=DVDD
XFE_PHC184_bus_wbuf_22 DEL1 $PINS I=bus_wbuf<22> Z=FE_PHN184_bus_wbuf_22
+ VSS=DVSS VDD=DVDD
XFE_PHC183_bus_wbuf_53 DEL1 $PINS I=FE_PHN442_bus_wbuf_53
+ Z=FE_PHN183_bus_wbuf_53 VSS=DVSS VDD=DVDD
XFE_PHC182_bus_wbuf_26 DEL1 $PINS I=FE_PHN463_bus_wbuf_26
+ Z=FE_PHN182_bus_wbuf_26 VSS=DVSS VDD=DVDD
XFE_PHC181_bus_wbuf_39 DEL1 $PINS I=FE_PHN421_bus_wbuf_39
+ Z=FE_PHN181_bus_wbuf_39 VSS=DVSS VDD=DVDD
XFE_PHC180_bus_wbuf_52 DEL1 $PINS I=FE_PHN454_bus_wbuf_52
+ Z=FE_PHN180_bus_wbuf_52 VSS=DVSS VDD=DVDD
XFE_PHC179_bus_wbuf_25 DEL1 $PINS I=bus_wbuf<25> Z=FE_PHN179_bus_wbuf_25
+ VSS=DVSS VDD=DVDD
XFE_PHC178_bus_wbuf_46 DEL1 $PINS I=bus_wbuf<46> Z=FE_PHN178_bus_wbuf_46
+ VSS=DVSS VDD=DVDD
XFE_PHC177_bus_wbuf_40 DEL1 $PINS I=FE_PHN453_bus_wbuf_40
+ Z=FE_PHN177_bus_wbuf_40 VSS=DVSS VDD=DVDD
XFE_PHC176_bus_wbuf_41 DEL1 $PINS I=FE_PHN426_bus_wbuf_41
+ Z=FE_PHN176_bus_wbuf_41 VSS=DVSS VDD=DVDD
XFE_PHC175_bus_wbuf_29 DEL1 $PINS I=FE_PHN417_bus_wbuf_29
+ Z=FE_PHN175_bus_wbuf_29 VSS=DVSS VDD=DVDD
XFE_PHC174_bus_wbuf_42 DEL1 $PINS I=bus_wbuf<42> Z=FE_PHN174_bus_wbuf_42
+ VSS=DVSS VDD=DVDD
XFE_PHC173_bus_wbuf_34 DEL1 $PINS I=bus_wbuf<34> Z=FE_PHN173_bus_wbuf_34
+ VSS=DVSS VDD=DVDD
XFE_PHC172_bus_wbuf_30 DEL1 $PINS I=bus_wbuf<30> Z=FE_PHN172_bus_wbuf_30
+ VSS=DVSS VDD=DVDD
XFE_PHC171_bus_wbuf_45 DEL1 $PINS I=bus_wbuf<45> Z=FE_PHN171_bus_wbuf_45
+ VSS=DVSS VDD=DVDD
XFE_PHC170_bus_wbuf_31 DEL1 $PINS I=bus_wbuf<31> Z=FE_PHN170_bus_wbuf_31
+ VSS=DVSS VDD=DVDD
XFE_PHC169_bus_wbuf_47 DEL1 $PINS I=FE_PHN418_bus_wbuf_47
+ Z=FE_PHN169_bus_wbuf_47 VSS=DVSS VDD=DVDD
XFE_PHC168_bus_wbuf_35 DEL1 $PINS I=FE_PHN409_bus_wbuf_35
+ Z=FE_PHN168_bus_wbuf_35 VSS=DVSS VDD=DVDD
XFE_PHC167_bus_wbuf_44 DEL1 $PINS I=bus_wbuf<44> Z=FE_PHN167_bus_wbuf_44
+ VSS=DVSS VDD=DVDD
XFE_PHC166_bus_wbuf_43 DEL1 $PINS I=bus_wbuf<43> Z=FE_PHN166_bus_wbuf_43
+ VSS=DVSS VDD=DVDD
XFE_PHC165_bus_wbuf_28 DEL1 $PINS I=bus_wbuf<28> Z=FE_PHN165_bus_wbuf_28
+ VSS=DVSS VDD=DVDD
XFE_PHC164_bus_wbuf_27 DEL1 $PINS I=bus_wbuf<27> Z=FE_PHN164_bus_wbuf_27
+ VSS=DVSS VDD=DVDD
XFE_PHC163_bus_addr_10 DEL1 $PINS I=FE_PHN373_bus_addr_10
+ Z=FE_PHN163_bus_addr_10 VSS=DVSS VDD=DVDD
XFE_PHC162_n_97 DEL1 $PINS I=n_97 Z=FE_PHN162_n_97 VSS=DVSS VDD=DVDD
XFE_PHC161_bus_wbuf_36 DEL1 $PINS I=bus_wbuf<36> Z=FE_PHN161_bus_wbuf_36
+ VSS=DVSS VDD=DVDD
XFE_PHC160_bus_addr_8 DEL1 $PINS I=FE_PHN305_bus_addr_8 Z=FE_PHN160_bus_addr_8
+ VSS=DVSS VDD=DVDD
XFE_PHC159_bus_addr_7 DEL1 $PINS I=FE_PHN306_bus_addr_7 Z=FE_PHN159_bus_addr_7
+ VSS=DVSS VDD=DVDD
XFE_PHC158_bus_addr_4 DEL1 $PINS I=FE_PHN304_bus_addr_4 Z=FE_PHN158_bus_addr_4
+ VSS=DVSS VDD=DVDD
XFE_PHC157_bus_addr_5 DEL1 $PINS I=FE_PHN302_bus_addr_5 Z=FE_PHN157_bus_addr_5
+ VSS=DVSS VDD=DVDD
XFE_PHC156_bus_addr_3 DEL1 $PINS I=FE_PHN303_bus_addr_3 Z=FE_PHN156_bus_addr_3
+ VSS=DVSS VDD=DVDD
XFE_PHC155_bus_addr_6 DEL1 $PINS I=FE_PHN301_bus_addr_6 Z=FE_PHN155_bus_addr_6
+ VSS=DVSS VDD=DVDD
XFE_PHC154_bus_addr_9 DEL1 $PINS I=FE_PHN300_bus_addr_9 Z=FE_PHN154_bus_addr_9
+ VSS=DVSS VDD=DVDD
XFE_PHC153_bus_addr_11 DEL1 $PINS I=FE_PHN299_bus_addr_11
+ Z=FE_PHN153_bus_addr_11 VSS=DVSS VDD=DVDD
XFE_PHC152_bus_addr_1 BUFFD2 $PINS I=bus_addr<1> Z=FE_PHN152_bus_addr_1
+ VSS=DVSS VDD=DVDD
XFE_PHC151_bus_addr_2 DEL1 $PINS I=bus_addr<2> Z=FE_PHN151_bus_addr_2 VSS=DVSS
+ VDD=DVDD
XFE_PHC150_bus_addr_0 DEL1 $PINS I=FE_PHN573_bus_addr_0 Z=FE_PHN150_bus_addr_0
+ VSS=DVSS VDD=DVDD
XFE_PHC149_tpu_dout_29 BUFFD8 $PINS I=FE_PHN240_tpu_dout_29 Z=tpu_dout<29>
+ VSS=DVSS VDD=DVDD
XFE_PHC147_tpu_dout_20 BUFFD8 $PINS I=FE_PHN245_tpu_dout_20 Z=tpu_dout<20>
+ VSS=DVSS VDD=DVDD
XFE_PHC145_tpu_dout_30 BUFFD8 $PINS I=FE_PHN239_tpu_dout_30 Z=tpu_dout<30>
+ VSS=DVSS VDD=DVDD
XFE_PHC143_tpu_dout_26 BUFFD8 $PINS I=FE_PHN243_tpu_dout_26 Z=tpu_dout<26>
+ VSS=DVSS VDD=DVDD
XFE_PHC141_tpu_dout_24 BUFFD8 $PINS I=FE_PHN241_tpu_dout_24 Z=tpu_dout<24>
+ VSS=DVSS VDD=DVDD
XFE_PHC139_tpu_dout_5 BUFFD8 $PINS I=FE_PHN286_tpu_dout_5 Z=tpu_dout<5>
+ VSS=DVSS VDD=DVDD
XFE_PHC137_tpu_dout_28 BUFFD8 $PINS I=FE_PHN246_tpu_dout_28 Z=tpu_dout<28>
+ VSS=DVSS VDD=DVDD
XFE_PHC135_tpu_dout_21 CKBD8 $PINS I=FE_PHN251_tpu_dout_21 Z=tpu_dout<21>
+ VSS=DVSS VDD=DVDD
XFE_PHC133_tpu_dout_25 BUFFD8 $PINS I=FE_PHN247_tpu_dout_25 Z=tpu_dout<25>
+ VSS=DVSS VDD=DVDD
XFE_PHC131_tpu_dout_27 BUFFD8 $PINS I=FE_PHN244_tpu_dout_27 Z=tpu_dout<27>
+ VSS=DVSS VDD=DVDD
XFE_PHC129_tpu_dout_13 BUFFD8 $PINS I=FE_PHN128_tpu_dout_13
+ Z=FE_PHN383_tpu_dout_13 VSS=DVSS VDD=DVDD
XFE_PHC127_tpu_dout_15 BUFFD8 $PINS I=FE_PHN504_tpu_dout_15 Z=tpu_dout<15>
+ VSS=DVSS VDD=DVDD
XFE_PHC125_tpu_dout_33 BUFFD8 $PINS I=FE_PHN252_tpu_dout_33 Z=tpu_dout<33>
+ VSS=DVSS VDD=DVDD
XFE_PHC123_tpu_dout_3 BUFFD8 $PINS I=FE_PHN258_tpu_dout_3 Z=tpu_dout<3>
+ VSS=DVSS VDD=DVDD
XFE_PHC121_tpu_dout_6 BUFFD8 $PINS I=FE_PHN273_tpu_dout_6 Z=tpu_dout<6>
+ VSS=DVSS VDD=DVDD
XFE_PHC119_tpu_dout_17 BUFFD8 $PINS I=FE_PHN249_tpu_dout_17 Z=tpu_dout<17>
+ VSS=DVSS VDD=DVDD
XFE_PHC117_tpu_dout_18 BUFFD8 $PINS I=FE_PHN250_tpu_dout_18 Z=tpu_dout<18>
+ VSS=DVSS VDD=DVDD
XFE_PHC115_tpu_dout_23 BUFFD8 $PINS I=FE_PHN484_tpu_dout_23 Z=tpu_dout<23>
+ VSS=DVSS VDD=DVDD
XFE_PHC113_tpu_dout_31 BUFFD8 $PINS I=FE_PHN112_tpu_dout_31
+ Z=FE_PHN312_tpu_dout_31 VSS=DVSS VDD=DVDD
XFE_PHC111_tpu_dout_46 BUFFD8 $PINS I=FE_PHN274_tpu_dout_46 Z=tpu_dout<46>
+ VSS=DVSS VDD=DVDD
XFE_PHC109_tpu_dout_44 BUFFD8 $PINS I=FE_PHN275_tpu_dout_44 Z=tpu_dout<44>
+ VSS=DVSS VDD=DVDD
XFE_PHC107_tpu_dout_42 BUFFD8 $PINS I=FE_PHN268_tpu_dout_42 Z=tpu_dout<42>
+ VSS=DVSS VDD=DVDD
XFE_PHC105_tpu_dout_4 BUFFD8 $PINS I=FE_PHN285_tpu_dout_4 Z=tpu_dout<4>
+ VSS=DVSS VDD=DVDD
XFE_PHC103_tpu_dout_0 BUFFD8 $PINS I=FE_PHN263_tpu_dout_0 Z=tpu_dout<0>
+ VSS=DVSS VDD=DVDD
XFE_PHC101_tpu_dout_9 BUFFD8 $PINS I=FE_PHN257_tpu_dout_9 Z=tpu_dout<9>
+ VSS=DVSS VDD=DVDD
XFE_PHC99_tpu_dout_11 BUFFD8 $PINS I=FE_PHN98_tpu_dout_11
+ Z=FE_PHN379_tpu_dout_11 VSS=DVSS VDD=DVDD
XFE_PHC97_tpu_dout_12 BUFFD8 $PINS I=FE_PHN96_tpu_dout_12
+ Z=FE_PHN381_tpu_dout_12 VSS=DVSS VDD=DVDD
XFE_PHC95_tpu_dout_19 BUFFD8 $PINS I=FE_PHN262_tpu_dout_19 Z=tpu_dout<19>
+ VSS=DVSS VDD=DVDD
XFE_PHC93_tpu_dout_40 CKBD8 $PINS I=FE_PHN270_tpu_dout_40 Z=tpu_dout<40>
+ VSS=DVSS VDD=DVDD
XFE_PHC91_tpu_dout_34 BUFFD8 $PINS I=FE_PHN260_tpu_dout_34 Z=tpu_dout<34>
+ VSS=DVSS VDD=DVDD
XFE_PHC89_tpu_dout_1 BUFFD8 $PINS I=FE_PHN266_tpu_dout_1 Z=tpu_dout<1> VSS=DVSS
+ VDD=DVDD
XFE_PHC87_tpu_dout_8 BUFFD8 $PINS I=FE_PHN255_tpu_dout_8 Z=tpu_dout<8> VSS=DVSS
+ VDD=DVDD
XFE_PHC85_tpu_dout_10 BUFFD8 $PINS I=FE_PHN256_tpu_dout_10 Z=tpu_dout<10>
+ VSS=DVSS VDD=DVDD
XFE_PHC83_tpu_dout_22 CKBD8 $PINS I=FE_PHN248_tpu_dout_22 Z=tpu_dout<22>
+ VSS=DVSS VDD=DVDD
XFE_PHC81_tpu_dout_41 BUFFD8 $PINS I=FE_PHN269_tpu_dout_41 Z=tpu_dout<41>
+ VSS=DVSS VDD=DVDD
XFE_PHC79_tpu_dout_38 CKBD12 $PINS I=FE_PHN271_tpu_dout_38 Z=tpu_dout<38>
+ VSS=DVSS VDD=DVDD
XFE_PHC77_tpu_dout_36 CKBD8 $PINS I=FE_PHN265_tpu_dout_36 Z=tpu_dout<36>
+ VSS=DVSS VDD=DVDD
XFE_PHC75_tpu_dout_37 CKBD8 $PINS I=FE_PHN264_tpu_dout_37 Z=tpu_dout<37>
+ VSS=DVSS VDD=DVDD
XFE_PHC73_tpu_dout_32 BUFFD8 $PINS I=FE_PHN261_tpu_dout_32 Z=tpu_dout<32>
+ VSS=DVSS VDD=DVDD
XFE_PHC71_tpu_dout_35 BUFFD8 $PINS I=FE_PHN259_tpu_dout_35 Z=tpu_dout<35>
+ VSS=DVSS VDD=DVDD
XFE_PHC69_tpu_dout_58 CKBD12 $PINS I=FE_PHN295_tpu_dout_58 Z=tpu_dout<58>
+ VSS=DVSS VDD=DVDD
XFE_PHC67_tpu_dout_55 CKBD12 $PINS I=FE_PHN288_tpu_dout_55 Z=tpu_dout<55>
+ VSS=DVSS VDD=DVDD
XFE_PHC65_tpu_dout_51 CKBD12 $PINS I=FE_PHN282_tpu_dout_51 Z=tpu_dout<51>
+ VSS=DVSS VDD=DVDD
XFE_PHC63_tpu_dout_45 BUFFD8 $PINS I=FE_PHN277_tpu_dout_45 Z=tpu_dout<45>
+ VSS=DVSS VDD=DVDD
XFE_PHC61_tpu_dout_43 BUFFD8 $PINS I=FE_PHN267_tpu_dout_43 Z=tpu_dout<43>
+ VSS=DVSS VDD=DVDD
XFE_PHC59_tpu_dout_7 CKBD12 $PINS I=FE_PHN280_tpu_dout_7 Z=tpu_dout<7> VSS=DVSS
+ VDD=DVDD
XFE_PHC57_tpu_dout_2 BUFFD8 $PINS I=FE_PHN272_tpu_dout_2 Z=tpu_dout<2> VSS=DVSS
+ VDD=DVDD
XFE_PHC55_tpu_dout_14 BUFFD8 $PINS I=FE_PHN54_tpu_dout_14
+ Z=FE_PHN385_tpu_dout_14 VSS=DVSS VDD=DVDD
XFE_PHC53_tpu_dout_16 BUFFD8 $PINS I=FE_PHN253_tpu_dout_16 Z=tpu_dout<16>
+ VSS=DVSS VDD=DVDD
XFE_PHC51_tpu_dout_60 CKBD12 $PINS I=FE_PHN293_tpu_dout_60 Z=tpu_dout<60>
+ VSS=DVSS VDD=DVDD
XFE_PHC49_tpu_dout_61 CKBD12 $PINS I=FE_PHN292_tpu_dout_61 Z=tpu_dout<61>
+ VSS=DVSS VDD=DVDD
XFE_PHC47_tpu_dout_54 CKBD12 $PINS I=FE_PHN296_tpu_dout_54 Z=tpu_dout<54>
+ VSS=DVSS VDD=DVDD
XFE_PHC45_tpu_dout_50 CKBD12 $PINS I=FE_PHN289_tpu_dout_50 Z=tpu_dout<50>
+ VSS=DVSS VDD=DVDD
XFE_PHC43_tpu_dout_48 CKBD12 $PINS I=FE_PHN283_tpu_dout_48 Z=tpu_dout<48>
+ VSS=DVSS VDD=DVDD
XFE_PHC41_tpu_dout_49 BUFFD8 $PINS I=FE_PHN281_tpu_dout_49 Z=tpu_dout<49>
+ VSS=DVSS VDD=DVDD
XFE_PHC39_tpu_dout_52 CKBD12 $PINS I=FE_PHN284_tpu_dout_52 Z=tpu_dout<52>
+ VSS=DVSS VDD=DVDD
XFE_PHC37_tpu_dout_47 CKBD12 $PINS I=FE_PHN279_tpu_dout_47 Z=tpu_dout<47>
+ VSS=DVSS VDD=DVDD
XFE_PHC35_tpu_dout_53 BUFFD8 $PINS I=FE_PHN278_tpu_dout_53 Z=tpu_dout<53>
+ VSS=DVSS VDD=DVDD
XFE_PHC33_tpu_dout_39 CKBD8 $PINS I=FE_PHN276_tpu_dout_39 Z=tpu_dout<39>
+ VSS=DVSS VDD=DVDD
XFE_PHC31_tpu_dout_57 CKBD12 $PINS I=FE_PHN294_tpu_dout_57 Z=tpu_dout<57>
+ VSS=DVSS VDD=DVDD
XFE_PHC29_tpu_dout_62 CKBD12 $PINS I=FE_PHN291_tpu_dout_62 Z=tpu_dout<62>
+ VSS=DVSS VDD=DVDD
XFE_PHC27_tpu_dout_63 CKBD12 $PINS I=FE_PHN290_tpu_dout_63 Z=tpu_dout<63>
+ VSS=DVSS VDD=DVDD
XFE_PHC25_tpu_dout_59 CKBD12 $PINS I=FE_PHN287_tpu_dout_59 Z=tpu_dout<59>
+ VSS=DVSS VDD=DVDD
XFE_PHC23_tpu_dout_56 BUFFD1 $PINS I=FE_PHN297_tpu_dout_56
+ Z=FE_PDN396_tpu_dout_56 VSS=DVSS VDD=DVDD
XFE_PHC21_last_word_addr_3 DEL2 $PINS I=last_word_addr<3>
+ Z=FE_PHN21_last_word_addr_3 VSS=DVSS VDD=DVDD
XFE_PHC20_last_word_addr_6 DEL2 $PINS I=last_word_addr<6>
+ Z=FE_PHN20_last_word_addr_6 VSS=DVSS VDD=DVDD
XFE_PHC19_last_word_addr_4 DEL2 $PINS I=last_word_addr<4>
+ Z=FE_PHN19_last_word_addr_4 VSS=DVSS VDD=DVDD
XFE_PHC18_last_word_addr_2 DEL2 $PINS I=last_word_addr<2>
+ Z=FE_PHN18_last_word_addr_2 VSS=DVSS VDD=DVDD
XFE_PHC17_last_word_addr_7 DEL2 $PINS I=last_word_addr<7>
+ Z=FE_PHN17_last_word_addr_7 VSS=DVSS VDD=DVDD
XFE_PHC16_last_word_addr_8 DEL2 $PINS I=last_word_addr<8>
+ Z=FE_PHN16_last_word_addr_8 VSS=DVSS VDD=DVDD
XFE_PHC15_last_word_addr_5 DEL2 $PINS I=last_word_addr<5>
+ Z=FE_PHN15_last_word_addr_5 VSS=DVSS VDD=DVDD
XFE_PHC14_last_word_addr_1 DEL2 $PINS I=last_word_addr<1>
+ Z=FE_PHN14_last_word_addr_1 VSS=DVSS VDD=DVDD
XFE_PHC13_last_word_addr_0 DEL2 $PINS I=last_word_addr<0>
+ Z=FE_PHN13_last_word_addr_0 VSS=DVSS VDD=DVDD
XFE_PHC12_bus_din_0 DEL1 $PINS I=bus_din<0> Z=FE_PHN12_bus_din_0 VSS=DVSS
+ VDD=DVDD
XFE_PHC11_bus_we_d1 CKBD1 $PINS I=bus_we_d1 Z=FE_PHN11_bus_we_d1 VSS=DVSS
+ VDD=DVDD
XFE_PHC10_bus_din_6 BUFFD2 $PINS I=bus_din<6> Z=FE_PHN618_bus_din_6 VSS=DVSS
+ VDD=DVDD
XFE_PHC9_bus_din_3 BUFFD2 $PINS I=bus_din<3> Z=FE_PHN606_bus_din_3 VSS=DVSS
+ VDD=DVDD
XFE_PHC8_bus_din_5 BUFFD2 $PINS I=bus_din<5> Z=FE_PHN8_bus_din_5 VSS=DVSS
+ VDD=DVDD
XFE_PHC7_bus_din_4 BUFFD2 $PINS I=FE_PHN687_bus_din_4 Z=FE_PHN619_bus_din_4
+ VSS=DVSS VDD=DVDD
XFE_PHC6_bus_din_7 BUFFD2 $PINS I=bus_din<7> Z=FE_PHN6_bus_din_7 VSS=DVSS
+ VDD=DVDD
XFE_PHC5_bus_din_1 BUFFD2 $PINS I=bus_din<1> Z=FE_PHN5_bus_din_1 VSS=DVSS
+ VDD=DVDD
XFE_PHC4_bus_din_2 BUFFD2 $PINS I=bus_din<2> Z=FE_PHN605_bus_din_2 VSS=DVSS
+ VDD=DVDD
XFE_PHC3_bus_we BUFFD1 $PINS I=FE_PHN576_bus_we Z=FE_PHN403_bus_we VSS=DVSS
+ VDD=DVDD
XFE_PHC2_flush_d1 DEL1 $PINS I=flush_d1 Z=FE_PHN2_flush_d1 VSS=DVSS VDD=DVDD
XCTS_ccl_a_inv_00005 CKND6 $PINS I=CTS_4 ZN=CTS_3 VSS=DVSS VDD=DVDD
XCTS_ccl_a_inv_00004 CKND2 $PINS I=CTS_4 ZN=CTS_2 VSS=DVSS VDD=DVDD
XCTS_ccl_a_inv_00003 CKND2 $PINS I=CTS_4 ZN=CTS_1 VSS=DVSS VDD=DVDD
XCTS_ccl_a_inv_00002 CKND3 $PINS I=CTS_4 ZN=CTS_6 VSS=DVSS VDD=DVDD
XCTS_ccl_a_inv_00001 CKND2 $PINS I=CTS_4 ZN=CTS_5 VSS=DVSS VDD=DVDD
XCTS_ccl_a_inv_00006 CKND6 $PINS I=CTS_7 ZN=CTS_4 VSS=DVSS VDD=DVDD
XCTS_ccl_a_inv_00007 CKND4 $PINS I=CTS_8 ZN=CTS_7 VSS=DVSS VDD=DVDD
XCTS_cmf_inv_00053 CKND1 $PINS I=clk ZN=CTS_8 VSS=DVSS VDD=DVDD
XLTIELO TIEL $PINS ZN=LTIELO_NET VSS=DVSS VDD=DVDD
XLTIEHI TIEH $PINS Z=LTIEHI_NET VSS=DVSS VDD=DVDD
XFE_OFC0_rstn CKBD3 $PINS I=FE_PHN218_rstn Z=FE_OFN0_rstn VSS=DVSS VDD=DVDD
Xu_sram sram00 $PINS Q<63>=FE_PHN26_tpu_dout_63 Q<62>=FE_PHN28_tpu_dout_62
+ Q<61>=FE_PHN48_tpu_dout_61 Q<60>=FE_PHN50_tpu_dout_60
+ Q<59>=FE_PHN24_tpu_dout_59 Q<58>=FE_PHN68_tpu_dout_58
+ Q<57>=FE_PHN30_tpu_dout_57 Q<56>=FE_PHN22_tpu_dout_56
+ Q<55>=FE_PHN66_tpu_dout_55 Q<54>=FE_PHN46_tpu_dout_54
+ Q<53>=FE_PHN34_tpu_dout_53 Q<52>=FE_PHN38_tpu_dout_52
+ Q<51>=FE_PHN64_tpu_dout_51 Q<50>=FE_PHN44_tpu_dout_50
+ Q<49>=FE_PHN40_tpu_dout_49 Q<48>=FE_PHN42_tpu_dout_48
+ Q<47>=FE_PHN36_tpu_dout_47 Q<46>=FE_PHN110_tpu_dout_46
+ Q<45>=FE_PHN62_tpu_dout_45 Q<44>=FE_PHN108_tpu_dout_44
+ Q<43>=FE_PHN60_tpu_dout_43 Q<42>=FE_PHN106_tpu_dout_42
+ Q<41>=FE_PHN80_tpu_dout_41 Q<40>=FE_PHN92_tpu_dout_40
+ Q<39>=FE_PHN32_tpu_dout_39 Q<38>=FE_PHN78_tpu_dout_38
+ Q<37>=FE_PHN74_tpu_dout_37 Q<36>=FE_PHN76_tpu_dout_36
+ Q<35>=FE_PHN70_tpu_dout_35 Q<34>=FE_PHN90_tpu_dout_34
+ Q<33>=FE_PHN124_tpu_dout_33 Q<32>=FE_PHN72_tpu_dout_32
+ Q<31>=FE_PHN112_tpu_dout_31 Q<30>=FE_PHN144_tpu_dout_30
+ Q<29>=FE_PHN148_tpu_dout_29 Q<28>=FE_PHN136_tpu_dout_28
+ Q<27>=FE_PHN130_tpu_dout_27 Q<26>=FE_PHN142_tpu_dout_26
+ Q<25>=FE_PHN132_tpu_dout_25 Q<24>=FE_PHN140_tpu_dout_24
+ Q<23>=FE_PHN114_tpu_dout_23 Q<22>=FE_PHN82_tpu_dout_22
+ Q<21>=FE_PHN134_tpu_dout_21 Q<20>=FE_PHN146_tpu_dout_20
+ Q<19>=FE_PHN94_tpu_dout_19 Q<18>=FE_PHN116_tpu_dout_18
+ Q<17>=FE_PHN118_tpu_dout_17 Q<16>=FE_PHN52_tpu_dout_16
+ Q<15>=FE_PHN126_tpu_dout_15 Q<14>=FE_PHN54_tpu_dout_14
+ Q<13>=FE_PHN128_tpu_dout_13 Q<12>=FE_PHN96_tpu_dout_12
+ Q<11>=FE_PHN98_tpu_dout_11 Q<10>=FE_PHN84_tpu_dout_10 Q<9>=FE_PHN100_tpu_dout_9
+ Q<8>=FE_PHN86_tpu_dout_8 Q<7>=FE_PHN58_tpu_dout_7 Q<6>=FE_PHN120_tpu_dout_6
+ Q<5>=FE_PHN138_tpu_dout_5 Q<4>=FE_PHN104_tpu_dout_4 Q<3>=FE_PHN122_tpu_dout_3
+ Q<2>=FE_PHN56_tpu_dout_2 Q<1>=FE_PHN88_tpu_dout_1 Q<0>=FE_PHN102_tpu_dout_0
+ CLK=CTS_3 CEN=FE_PHN217_sram_cen WEN=FE_PHN310_sram_wen
+ A<8>=FE_PHN235_sram_addr_8 A<7>=FE_PHN234_sram_addr_7
+ A<6>=FE_PHN357_sram_addr_6 A<5>=FE_PHN508_sram_addr_5
+ A<4>=FE_PHN320_sram_addr_4 A<3>=FE_PHN345_sram_addr_3
+ A<2>=FE_PHN547_sram_addr_2 A<1>=FE_PHN545_sram_addr_1
+ A<0>=FE_PHN591_sram_addr_0 D<63>=FE_PHN225_bus_wbuf_63
+ D<62>=FE_PHN371_bus_wbuf_62 D<61>=FE_PHN549_bus_wbuf_61
+ D<60>=FE_PHN369_bus_wbuf_60 D<59>=FE_PHN224_bus_wbuf_59
+ D<58>=FE_PHN226_bus_wbuf_58 D<57>=FE_PHN227_bus_wbuf_57
+ D<56>=FE_PHN228_bus_wbuf_56 D<55>=FE_PHN348_bus_wbuf_55
+ D<54>=FE_PHN360_bus_wbuf_54 D<53>=FE_PHN338_bus_wbuf_53
+ D<52>=FE_PHN335_bus_wbuf_52 D<51>=FE_PHN577_bus_wbuf_51
+ D<50>=FE_PHN349_bus_wbuf_50 D<49>=FE_PHN347_bus_wbuf_49
+ D<48>=FE_PHN374_bus_wbuf_48 D<47>=FE_PHN324_bus_wbuf_47
+ D<46>=FE_PHN334_bus_wbuf_46 D<45>=FE_PHN327_bus_wbuf_45
+ D<44>=FE_PHN325_bus_wbuf_44 D<43>=FE_PHN323_bus_wbuf_43
+ D<42>=FE_PHN326_bus_wbuf_42 D<41>=FE_PHN332_bus_wbuf_41
+ D<40>=FE_PHN331_bus_wbuf_40 D<39>=FE_PHN330_bus_wbuf_39
+ D<38>=FE_PHN342_bus_wbuf_38 D<37>=FE_PHN339_bus_wbuf_37
+ D<36>=FE_PHN316_bus_wbuf_36 D<35>=FE_PHN319_bus_wbuf_35
+ D<34>=FE_PHN318_bus_wbuf_34 D<33>=FE_PHN340_bus_wbuf_33
+ D<32>=FE_PHN344_bus_wbuf_32 D<31>=FE_PHN321_bus_wbuf_31
+ D<30>=FE_PHN322_bus_wbuf_30 D<29>=FE_PHN329_bus_wbuf_29
+ D<28>=FE_PHN328_bus_wbuf_28 D<27>=FE_PHN317_bus_wbuf_27
+ D<26>=FE_PHN346_bus_wbuf_26 D<25>=FE_PHN353_bus_wbuf_25
+ D<24>=FE_PHN350_bus_wbuf_24 D<23>=FE_PHN337_bus_wbuf_23
+ D<22>=FE_PHN333_bus_wbuf_22 D<21>=FE_PHN336_bus_wbuf_21
+ D<20>=FE_PHN343_bus_wbuf_20 D<19>=FE_PHN388_bus_wbuf_19
+ D<18>=FE_PHN358_bus_wbuf_18 D<17>=FE_PHN355_bus_wbuf_17
+ D<16>=FE_PHN197_bus_wbuf_16 D<15>=FE_PHN208_bus_wbuf_15
+ D<14>=FE_PHN202_bus_wbuf_14 D<13>=FE_PHN361_bus_wbuf_13
+ D<12>=FE_PHN359_bus_wbuf_12 D<11>=FE_PHN363_bus_wbuf_11
+ D<10>=FE_PHN356_bus_wbuf_10 D<9>=FE_PHN387_bus_wbuf_9 D<8>=FE_PHN389_bus_wbuf_8
+ D<7>=FE_PHN220_bus_wbuf_7 D<6>=FE_PHN219_bus_wbuf_6 D<5>=FE_PHN214_bus_wbuf_5
+ D<4>=FE_PHN216_bus_wbuf_4 D<3>=FE_PHN215_bus_wbuf_3 D<2>=FE_PHN213_bus_wbuf_2
+ D<1>=FE_PHN367_bus_wbuf_1 D<0>=FE_PHN212_bus_wbuf_0 EMA<2>=LTIELO_NET
+ EMA<1>=LTIEHI_NET EMA<0>=LTIELO_NET RETN=LTIEHI_NET VSS=DVSS VDD=DVDD
Xp96110A__2398 AO222D1 $PINS A1=n_98 A2=flush_addr<4> B1=tpu_addr<4>
+ B2=sram_wen C1=FE_PHN11_bus_we_d1 C2=bus_waddr_d1<4> Z=sram_addr<4> VSS=DVSS
+ VDD=DVDD
Xp96116A__5107 AO222D0 $PINS A1=n_98 A2=flush_addr<6> B1=sram_wen
+ B2=tpu_addr<6> C1=FE_PHN11_bus_we_d1 C2=bus_waddr_d1<6> Z=sram_addr<6> VSS=DVSS
+ VDD=DVDD
Xp96116A2176__6260 AO222D0 $PINS A1=n_98 A2=flush_addr<8> B1=sram_wen
+ B2=tpu_addr<8> C1=FE_PHN11_bus_we_d1 C2=bus_waddr_d1<8> Z=sram_addr<8> VSS=DVSS
+ VDD=DVDD
Xp96116A2177__4319 AO222D1 $PINS A1=n_98 A2=flush_addr<0> B1=sram_wen
+ B2=tpu_addr<0> C1=FE_PHN11_bus_we_d1 C2=bus_waddr_d1<0> Z=sram_addr<0> VSS=DVSS
+ VDD=DVDD
Xp96116A2178__8428 AO222D1 $PINS A1=n_98 A2=flush_addr<2> B1=sram_wen
+ B2=tpu_addr<2> C1=FE_PHN11_bus_we_d1 C2=bus_waddr_d1<2> Z=sram_addr<2> VSS=DVSS
+ VDD=DVDD
Xp96116A2179__5526 AO222D0 $PINS A1=n_98 A2=flush_addr<7> B1=sram_wen
+ B2=tpu_addr<7> C1=FE_PHN11_bus_we_d1 C2=bus_waddr_d1<7> Z=sram_addr<7> VSS=DVSS
+ VDD=DVDD
Xp96116A2180__6783 AO222D1 $PINS A1=n_98 A2=flush_addr<3> B1=sram_wen
+ B2=tpu_addr<3> C1=FE_PHN11_bus_we_d1 C2=bus_waddr_d1<3> Z=sram_addr<3> VSS=DVSS
+ VDD=DVDD
Xp96116A2181__3680 AO222D0 $PINS A1=n_98 A2=flush_addr<5> B1=sram_wen
+ B2=tpu_addr<5> C1=FE_PHN11_bus_we_d1 C2=bus_waddr_d1<5> Z=sram_addr<5> VSS=DVSS
+ VDD=DVDD
Xp96110A2182__1617 AO222D1 $PINS A1=n_98 A2=flush_addr<1> B1=tpu_addr<1>
+ B2=sram_wen C1=FE_PHN11_bus_we_d1 C2=bus_waddr_d1<1> Z=sram_addr<1> VSS=DVSS
+ VDD=DVDD
Xp96014A__2802 NR2D2 $PINS A1=FE_PHN11_bus_we_d1 A2=FE_PHN2_flush_d1
+ ZN=sram_wen VSS=DVSS VDD=DVDD
Xp96110A2183__1705 INR2D1 $PINS A1=FE_PHN2_flush_d1 B1=FE_PHN11_bus_we_d1
+ ZN=n_98 VSS=DVSS VDD=DVDD
Xflush_d1_reg DFCNQD1 $PINS CDN=FE_OFN0_rstn CP=CTS_1 D=FE_PHN162_n_97
+ Q=flush_d1 VSS=DVSS VDD=DVDD
Xp96217A__5122 INR3D0 $PINS A1=bus_we_prev B1=FE_PHN620_bus_we B2=n_95
+ ZN=FE_PHN511_n_97 VSS=DVSS VDD=DVDD
Xbus_we_d1_reg DFCNQD1 $PINS CDN=FE_PHN218_rstn CP=CTS_1 D=FE_PHN517_n_96
+ Q=bus_we_d1 VSS=DVSS VDD=DVDD
XFp96510A CKND0 $PINS I=FE_PHN517_n_96 ZN=n_101 VSS=DVSS VDD=DVDD
Xp96479A__8246 NR2D0 $PINS A1=n_103 A2=n_102 ZN=n_96 VSS=DVSS VDD=DVDD
Xp96214A__7098 AN3D0 $PINS A1=last_byte_sel<1> A2=last_byte_sel<2>
+ A3=last_byte_sel<0> Z=n_95 VSS=DVSS VDD=DVDD
Xbus_waddr_d1_reg[1] DFCNQD1 $PINS CDN=FE_OFN0_rstn CP=CTS_6
+ D=FE_PHN585_bus_addr_4 Q=bus_waddr_d1<1> VSS=DVSS VDD=DVDD
Xbus_waddr_d1_reg[7] DFCNQD1 $PINS CDN=FE_OFN0_rstn CP=CTS_5
+ D=FE_PHN163_bus_addr_10 Q=bus_waddr_d1<7> VSS=DVSS VDD=DVDD
Xbus_waddr_d1_reg[5] DFCNQD1 $PINS CDN=FE_OFN0_rstn CP=CTS_6
+ D=FE_PHN570_bus_addr_8 Q=bus_waddr_d1<5> VSS=DVSS VDD=DVDD
Xflush_addr_reg[5] DFCNQD1 $PINS CDN=FE_OFN0_rstn CP=CTS_6
+ D=FE_PHN15_last_word_addr_5 Q=flush_addr<5> VSS=DVSS VDD=DVDD
Xbus_we_prev_reg DFCNQD1 $PINS CDN=FE_OFN0_rstn CP=CTS_1 D=FE_PHN598_bus_we
+ Q=bus_we_prev VSS=DVSS VDD=DVDD
Xbus_waddr_d1_reg[0] DFCNQD1 $PINS CDN=FE_OFN0_rstn CP=CTS_6
+ D=FE_PHN584_bus_addr_3 Q=bus_waddr_d1<0> VSS=DVSS VDD=DVDD
Xflush_addr_reg[0] DFCNQD1 $PINS CDN=FE_OFN0_rstn CP=CTS_6
+ D=FE_PHN13_last_word_addr_0 Q=flush_addr<0> VSS=DVSS VDD=DVDD
Xbus_waddr_d1_reg[8] DFCNQD1 $PINS CDN=FE_OFN0_rstn CP=CTS_5
+ D=FE_PHN153_bus_addr_11 Q=bus_waddr_d1<8> VSS=DVSS VDD=DVDD
Xflush_addr_reg[4] DFCNQD1 $PINS CDN=FE_OFN0_rstn CP=CTS_6
+ D=FE_PHN19_last_word_addr_4 Q=flush_addr<4> VSS=DVSS VDD=DVDD
Xflush_addr_reg[7] DFCNQD1 $PINS CDN=FE_OFN0_rstn CP=CTS_5
+ D=FE_PHN17_last_word_addr_7 Q=flush_addr<7> VSS=DVSS VDD=DVDD
Xbus_waddr_d1_reg[6] DFCNQD1 $PINS CDN=FE_OFN0_rstn CP=CTS_5
+ D=FE_PHN582_bus_addr_9 Q=bus_waddr_d1<6> VSS=DVSS VDD=DVDD
Xbus_waddr_d1_reg[4] DFCNQD1 $PINS CDN=FE_OFN0_rstn CP=CTS_6
+ D=FE_PHN587_bus_addr_7 Q=bus_waddr_d1<4> VSS=DVSS VDD=DVDD
Xflush_addr_reg[8] DFCNQD1 $PINS CDN=FE_OFN0_rstn CP=CTS_5
+ D=FE_PHN16_last_word_addr_8 Q=flush_addr<8> VSS=DVSS VDD=DVDD
Xbus_waddr_d1_reg[3] DFCNQD1 $PINS CDN=FE_OFN0_rstn CP=CTS_6
+ D=FE_PHN581_bus_addr_6 Q=bus_waddr_d1<3> VSS=DVSS VDD=DVDD
Xflush_addr_reg[3] DFCNQD1 $PINS CDN=FE_OFN0_rstn CP=CTS_6
+ D=FE_PHN21_last_word_addr_3 Q=flush_addr<3> VSS=DVSS VDD=DVDD
Xflush_addr_reg[6] DFCNQD1 $PINS CDN=FE_OFN0_rstn CP=CTS_6
+ D=FE_PHN20_last_word_addr_6 Q=flush_addr<6> VSS=DVSS VDD=DVDD
Xbus_waddr_d1_reg[2] DFCNQD1 $PINS CDN=FE_OFN0_rstn CP=CTS_6
+ D=FE_PHN583_bus_addr_5 Q=bus_waddr_d1<2> VSS=DVSS VDD=DVDD
Xflush_addr_reg[2] DFCNQD1 $PINS CDN=FE_OFN0_rstn CP=CTS_6
+ D=FE_PHN18_last_word_addr_2 Q=flush_addr<2> VSS=DVSS VDD=DVDD
Xflush_addr_reg[1] DFCNQD1 $PINS CDN=FE_OFN0_rstn CP=CTS_6
+ D=FE_PHN14_last_word_addr_1 Q=flush_addr<1> VSS=DVSS VDD=DVDD
Xp96361A__6131 CKND2D0 $PINS A1=FE_PHN620_bus_we A2=FE_PHN152_bus_addr_1
+ ZN=n_103 VSS=DVSS VDD=DVDD
Xp96404A__1881 CKND2D0 $PINS A1=FE_PHN151_bus_addr_2 A2=FE_PHN150_bus_addr_0
+ ZN=n_102 VSS=DVSS VDD=DVDD
Xg2__5115 INR2D0 $PINS A1=sram_wen B1=FE_PHN298_tpu_re ZN=sram_cen VSS=DVSS
+ VDD=DVDD
Xbus_wbuf_reg[0] DFCNQD1 $PINS CDN=FE_OFN0_rstn CP=CTS_5 D=n_41 Q=bus_wbuf<0>
+ VSS=DVSS VDD=DVDD
Xbus_wbuf_reg[1] DFCNQD1 $PINS CDN=FE_OFN0_rstn CP=CTS_5 D=n_38 Q=bus_wbuf<1>
+ VSS=DVSS VDD=DVDD
Xbus_wbuf_reg[2] DFCNQD1 $PINS CDN=FE_OFN0_rstn CP=CTS_5 D=n_42 Q=bus_wbuf<2>
+ VSS=DVSS VDD=DVDD
Xbus_wbuf_reg[3] DFCNQD1 $PINS CDN=FE_OFN0_rstn CP=CTS_5 D=n_43 Q=bus_wbuf<3>
+ VSS=DVSS VDD=DVDD
Xbus_wbuf_reg[4] DFCNQD1 $PINS CDN=FE_OFN0_rstn CP=CTS_5 D=n_37 Q=bus_wbuf<4>
+ VSS=DVSS VDD=DVDD
Xbus_wbuf_reg[5] DFCNQD1 $PINS CDN=FE_OFN0_rstn CP=CTS_5 D=n_36 Q=bus_wbuf<5>
+ VSS=DVSS VDD=DVDD
Xbus_wbuf_reg[6] DFCNQD1 $PINS CDN=FE_OFN0_rstn CP=CTS_1 D=n_39 Q=bus_wbuf<6>
+ VSS=DVSS VDD=DVDD
Xbus_wbuf_reg[7] DFCNQD1 $PINS CDN=FE_OFN0_rstn CP=CTS_1 D=n_40 Q=bus_wbuf<7>
+ VSS=DVSS VDD=DVDD
Xbus_wbuf_reg[8] DFCNQD1 $PINS CDN=FE_OFN0_rstn CP=CTS_5 D=n_65 Q=bus_wbuf<8>
+ VSS=DVSS VDD=DVDD
Xbus_wbuf_reg[9] DFCNQD1 $PINS CDN=FE_OFN0_rstn CP=CTS_5 D=n_59
+ Q=FE_PHN578_bus_wbuf_9 VSS=DVSS VDD=DVDD
Xbus_wbuf_reg[10] DFCNQD1 $PINS CDN=FE_OFN0_rstn CP=CTS_5 D=n_58
+ Q=FE_PHN563_bus_wbuf_10 VSS=DVSS VDD=DVDD
Xbus_wbuf_reg[11] DFCNQD1 $PINS CDN=FE_OFN0_rstn CP=CTS_5 D=n_55
+ Q=FE_PHN438_bus_wbuf_11 VSS=DVSS VDD=DVDD
Xbus_wbuf_reg[12] DFCNQD1 $PINS CDN=FE_OFN0_rstn CP=CTS_5 D=n_52
+ Q=FE_PHN444_bus_wbuf_12 VSS=DVSS VDD=DVDD
Xbus_wbuf_reg[13] DFCNQD1 $PINS CDN=FE_OFN0_rstn CP=CTS_5 D=n_51
+ Q=FE_PHN439_bus_wbuf_13 VSS=DVSS VDD=DVDD
Xbus_wbuf_reg[14] DFCNQD1 $PINS CDN=FE_OFN0_rstn CP=CTS_5 D=n_50 Q=bus_wbuf<14>
+ VSS=DVSS VDD=DVDD
Xbus_wbuf_reg[15] DFCNQD1 $PINS CDN=FE_OFN0_rstn CP=CTS_1 D=n_49 Q=bus_wbuf<15>
+ VSS=DVSS VDD=DVDD
Xbus_wbuf_reg[16] DFCNQD1 $PINS CDN=FE_OFN0_rstn CP=CTS_1 D=n_35 Q=bus_wbuf<16>
+ VSS=DVSS VDD=DVDD
Xbus_wbuf_reg[17] DFCNQD1 $PINS CDN=FE_OFN0_rstn CP=CTS_1 D=FE_PHN526_n_34
+ Q=FE_PHN413_bus_wbuf_17 VSS=DVSS VDD=DVDD
Xbus_wbuf_reg[18] DFCNQD1 $PINS CDN=FE_OFN0_rstn CP=CTS_1 D=n_33 Q=bus_wbuf<18>
+ VSS=DVSS VDD=DVDD
Xbus_wbuf_reg[19] DFCNQD1 $PINS CDN=FE_OFN0_rstn CP=CTS_1 D=FE_PHN528_n_32
+ Q=FE_PHN416_bus_wbuf_19 VSS=DVSS VDD=DVDD
Xbus_wbuf_reg[20] DFCNQD1 $PINS CDN=FE_OFN0_rstn CP=CTS_1 D=FE_PHN525_n_31
+ Q=bus_wbuf<20> VSS=DVSS VDD=DVDD
Xbus_wbuf_reg[21] DFCNQD1 $PINS CDN=FE_OFN0_rstn CP=CTS_1 D=n_30
+ Q=FE_PHN446_bus_wbuf_21 VSS=DVSS VDD=DVDD
Xbus_wbuf_reg[22] DFCNQD1 $PINS CDN=FE_OFN0_rstn CP=CTS_1 D=FE_PHN613_n_29
+ Q=FE_PHN445_bus_wbuf_22 VSS=DVSS VDD=DVDD
Xbus_wbuf_reg[23] DFCNQD1 $PINS CDN=FE_OFN0_rstn CP=CTS_1 D=FE_PHN529_n_28
+ Q=bus_wbuf<23> VSS=DVSS VDD=DVDD
Xbus_wbuf_reg[24] DFCNQD1 $PINS CDN=FE_OFN0_rstn CP=CTS_1 D=n_78 Q=bus_wbuf<24>
+ VSS=DVSS VDD=DVDD
Xbus_wbuf_reg[25] DFCNQD1 $PINS CDN=FE_PHN218_rstn CP=CTS_1 D=FE_PHN612_n_77
+ Q=FE_PHN408_bus_wbuf_25 VSS=DVSS VDD=DVDD
Xbus_wbuf_reg[26] DFCNQD1 $PINS CDN=FE_PHN218_rstn CP=CTS_1 D=FE_PHN590_n_76
+ Q=bus_wbuf<26> VSS=DVSS VDD=DVDD
Xbus_wbuf_reg[27] DFCNQD1 $PINS CDN=FE_PHN218_rstn CP=CTS_3 D=n_75
+ Q=FE_PHN429_bus_wbuf_27 VSS=DVSS VDD=DVDD
Xbus_wbuf_reg[28] DFCNQD1 $PINS CDN=FE_PHN218_rstn CP=CTS_3 D=n_74
+ Q=FE_PHN422_bus_wbuf_28 VSS=DVSS VDD=DVDD
Xbus_wbuf_reg[29] DFCNQD1 $PINS CDN=FE_PHN218_rstn CP=CTS_3 D=FE_PHN542_n_73
+ Q=bus_wbuf<29> VSS=DVSS VDD=DVDD
Xbus_wbuf_reg[30] DFCNQD1 $PINS CDN=FE_PHN218_rstn CP=CTS_3 D=FE_PHN541_n_72
+ Q=FE_PHN415_bus_wbuf_30 VSS=DVSS VDD=DVDD
Xbus_wbuf_reg[31] DFCNQD1 $PINS CDN=FE_PHN218_rstn CP=CTS_3 D=FE_PHN540_n_71
+ Q=FE_PHN424_bus_wbuf_31 VSS=DVSS VDD=DVDD
Xbus_wbuf_reg[32] DFCNQD1 $PINS CDN=FE_PHN218_rstn CP=CTS_3 D=n_48
+ Q=FE_PHN414_bus_wbuf_32 VSS=DVSS VDD=DVDD
Xbus_wbuf_reg[33] DFCNQD1 $PINS CDN=FE_PHN218_rstn CP=CTS_3 D=n_47
+ Q=bus_wbuf<33> VSS=DVSS VDD=DVDD
Xbus_wbuf_reg[34] DFCNQD1 $PINS CDN=FE_PHN218_rstn CP=CTS_3 D=n_68
+ Q=FE_PHN411_bus_wbuf_34 VSS=DVSS VDD=DVDD
Xbus_wbuf_reg[35] DFCNQD1 $PINS CDN=FE_PHN218_rstn CP=CTS_3 D=n_69
+ Q=bus_wbuf<35> VSS=DVSS VDD=DVDD
Xbus_wbuf_reg[36] DFCNQD1 $PINS CDN=FE_PHN218_rstn CP=CTS_3 D=n_70
+ Q=FE_PHN410_bus_wbuf_36 VSS=DVSS VDD=DVDD
Xbus_wbuf_reg[37] DFCNQD1 $PINS CDN=FE_PHN218_rstn CP=CTS_3 D=n_67
+ Q=bus_wbuf<37> VSS=DVSS VDD=DVDD
Xbus_wbuf_reg[38] DFCNQD1 $PINS CDN=FE_PHN218_rstn CP=CTS_3 D=n_66
+ Q=bus_wbuf<38> VSS=DVSS VDD=DVDD
Xbus_wbuf_reg[39] DFCNQD1 $PINS CDN=FE_PHN218_rstn CP=CTS_3 D=n_64
+ Q=bus_wbuf<39> VSS=DVSS VDD=DVDD
Xbus_wbuf_reg[40] DFCNQD1 $PINS CDN=FE_PHN218_rstn CP=CTS_2 D=n_63
+ Q=bus_wbuf<40> VSS=DVSS VDD=DVDD
Xbus_wbuf_reg[41] DFCNQD1 $PINS CDN=FE_PHN218_rstn CP=CTS_2 D=FE_PHN521_n_62
+ Q=bus_wbuf<41> VSS=DVSS VDD=DVDD
Xbus_wbuf_reg[42] DFCNQD1 $PINS CDN=FE_PHN218_rstn CP=CTS_2 D=FE_PHN523_n_61
+ Q=FE_PHN427_bus_wbuf_42 VSS=DVSS VDD=DVDD
Xbus_wbuf_reg[43] DFCNQD1 $PINS CDN=FE_PHN218_rstn CP=CTS_2 D=n_60
+ Q=FE_PHN428_bus_wbuf_43 VSS=DVSS VDD=DVDD
Xbus_wbuf_reg[44] DFCNQD1 $PINS CDN=FE_PHN218_rstn CP=CTS_2 D=n_57
+ Q=FE_PHN455_bus_wbuf_44 VSS=DVSS VDD=DVDD
Xbus_wbuf_reg[45] DFCNQD1 $PINS CDN=FE_PHN218_rstn CP=CTS_2 D=n_56
+ Q=FE_PHN425_bus_wbuf_45 VSS=DVSS VDD=DVDD
Xbus_wbuf_reg[46] DFCNQD1 $PINS CDN=FE_PHN218_rstn CP=CTS_2 D=FE_PHN524_n_54
+ Q=FE_PHN449_bus_wbuf_46 VSS=DVSS VDD=DVDD
Xbus_wbuf_reg[47] DFCNQD1 $PINS CDN=FE_PHN218_rstn CP=CTS_2 D=FE_PHN518_n_53
+ Q=bus_wbuf<47> VSS=DVSS VDD=DVDD
Xbus_wbuf_reg[48] DFCNQD1 $PINS CDN=FE_PHN218_rstn CP=CTS_2 D=n_94
+ Q=FE_PHN406_bus_wbuf_48 VSS=DVSS VDD=DVDD
Xbus_wbuf_reg[49] DFCNQD1 $PINS CDN=FE_PHN218_rstn CP=CTS_2 D=FE_PHN537_n_93
+ Q=FE_PHN441_bus_wbuf_49 VSS=DVSS VDD=DVDD
Xbus_wbuf_reg[50] DFCNQD1 $PINS CDN=FE_PHN218_rstn CP=CTS_2 D=FE_PHN535_n_92
+ Q=bus_wbuf<50> VSS=DVSS VDD=DVDD
Xbus_wbuf_reg[51] DFCNQD1 $PINS CDN=FE_PHN218_rstn CP=CTS_2 D=FE_PHN534_n_91
+ Q=bus_wbuf<51> VSS=DVSS VDD=DVDD
Xbus_wbuf_reg[52] DFCNQD1 $PINS CDN=FE_PHN218_rstn CP=CTS_2 D=FE_PHN538_n_90
+ Q=bus_wbuf<52> VSS=DVSS VDD=DVDD
Xbus_wbuf_reg[53] DFCNQD1 $PINS CDN=FE_PHN218_rstn CP=CTS_2 D=FE_PHN543_n_89
+ Q=bus_wbuf<53> VSS=DVSS VDD=DVDD
Xbus_wbuf_reg[54] DFCNQD1 $PINS CDN=FE_PHN218_rstn CP=CTS_2 D=FE_PHN536_n_88
+ Q=bus_wbuf<54> VSS=DVSS VDD=DVDD
Xbus_wbuf_reg[55] DFCNQD1 $PINS CDN=FE_PHN311_rstn CP=CTS_2 D=FE_PHN539_n_87
+ Q=bus_wbuf<55> VSS=DVSS VDD=DVDD
Xbus_wbuf_reg[56] DFCNQD1 $PINS CDN=FE_PHN218_rstn CP=CTS_3 D=n_86
+ Q=FE_PHN399_bus_wbuf_56 VSS=DVSS VDD=DVDD
Xbus_wbuf_reg[57] DFCNQD1 $PINS CDN=FE_PHN218_rstn CP=CTS_3 D=n_85
+ Q=FE_PHN400_bus_wbuf_57 VSS=DVSS VDD=DVDD
Xbus_wbuf_reg[58] DFCNQD1 $PINS CDN=FE_PHN218_rstn CP=CTS_3 D=n_84
+ Q=bus_wbuf<58> VSS=DVSS VDD=DVDD
Xbus_wbuf_reg[59] DFCNQD1 $PINS CDN=FE_PHN218_rstn CP=CTS_3 D=n_83
+ Q=bus_wbuf<59> VSS=DVSS VDD=DVDD
Xbus_wbuf_reg[60] DFCNQD1 $PINS CDN=FE_PHN218_rstn CP=CTS_2 D=n_82
+ Q=bus_wbuf<60> VSS=DVSS VDD=DVDD
Xbus_wbuf_reg[61] DFCNQD1 $PINS CDN=FE_PHN218_rstn CP=CTS_2 D=n_81
+ Q=bus_wbuf<61> VSS=DVSS VDD=DVDD
Xbus_wbuf_reg[62] DFCNQD1 $PINS CDN=FE_PHN218_rstn CP=CTS_2 D=n_80
+ Q=bus_wbuf<62> VSS=DVSS VDD=DVDD
Xbus_wbuf_reg[63] DFCNQD1 $PINS CDN=FE_PHN218_rstn CP=CTS_2 D=n_79
+ Q=bus_wbuf<63> VSS=DVSS VDD=DVDD
Xlast_byte_sel_reg[0] EDFCNQD1 $PINS CDN=FE_OFN0_rstn CP=CTS_1
+ D=FE_PHN614_bus_addr_0 E=FE_PHN600_bus_we Q=last_byte_sel<0> VSS=DVSS VDD=DVDD
Xlast_byte_sel_reg[1] EDFCNQD4 $PINS CDN=FE_PHN218_rstn CP=CTS_1
+ D=FE_PHN558_bus_addr_1 E=FE_PHN620_bus_we Q=last_byte_sel<1> VSS=DVSS VDD=DVDD
Xlast_byte_sel_reg[2] EDFCNQD1 $PINS CDN=FE_PHN218_rstn CP=CTS_1
+ D=FE_PHN509_bus_addr_2 E=FE_PHN602_bus_we Q=last_byte_sel<2> VSS=DVSS VDD=DVDD
Xlast_word_addr_reg[0] EDFCNQD1 $PINS CDN=FE_OFN0_rstn CP=CTS_6
+ D=FE_PHN156_bus_addr_3 E=FE_PHN611_bus_we Q=last_word_addr<0> VSS=DVSS VDD=DVDD
Xlast_word_addr_reg[1] EDFCNQD1 $PINS CDN=FE_OFN0_rstn CP=CTS_6
+ D=FE_PHN158_bus_addr_4 E=FE_PHN611_bus_we Q=last_word_addr<1> VSS=DVSS VDD=DVDD
Xlast_word_addr_reg[2] EDFCNQD1 $PINS CDN=FE_OFN0_rstn CP=CTS_6
+ D=FE_PHN157_bus_addr_5 E=FE_PHN620_bus_we Q=last_word_addr<2> VSS=DVSS VDD=DVDD
Xlast_word_addr_reg[3] EDFCNQD1 $PINS CDN=FE_OFN0_rstn CP=CTS_6
+ D=FE_PHN155_bus_addr_6 E=FE_PHN620_bus_we Q=last_word_addr<3> VSS=DVSS VDD=DVDD
Xlast_word_addr_reg[4] EDFCNQD1 $PINS CDN=FE_OFN0_rstn CP=CTS_6
+ D=FE_PHN159_bus_addr_7 E=FE_PHN620_bus_we Q=last_word_addr<4> VSS=DVSS VDD=DVDD
Xlast_word_addr_reg[5] EDFCNQD1 $PINS CDN=FE_OFN0_rstn CP=CTS_6
+ D=FE_PHN512_bus_addr_8 E=FE_PHN620_bus_we Q=last_word_addr<5> VSS=DVSS VDD=DVDD
Xlast_word_addr_reg[6] EDFCNQD1 $PINS CDN=FE_OFN0_rstn CP=CTS_6
+ D=FE_PHN154_bus_addr_9 E=FE_PHN620_bus_we Q=last_word_addr<6> VSS=DVSS VDD=DVDD
Xlast_word_addr_reg[7] EDFCNQD1 $PINS CDN=FE_OFN0_rstn CP=CTS_5
+ D=FE_PHN615_bus_addr_10 E=FE_PHN620_bus_we Q=last_word_addr<7> VSS=DVSS
+ VDD=DVDD
Xlast_word_addr_reg[8] EDFCNQD1 $PINS CDN=FE_OFN0_rstn CP=CTS_5
+ D=FE_PHN153_bus_addr_11 E=FE_PHN620_bus_we Q=last_word_addr<8> VSS=DVSS
+ VDD=DVDD
Xp96178A__7482 AO22D0 $PINS A1=FE_PHN210_bus_wbuf_48 A2=FE_PHN514_n_45
+ B1=FE_PHN622_bus_din_0 B2=FE_PHN515_n_17 Z=n_94 VSS=DVSS VDD=DVDD
Xp96178A3140__4733 AO22D0 $PINS A1=FE_PHN193_bus_wbuf_49 A2=FE_PHN514_n_45
+ B1=FE_PHN616_bus_din_1 B2=FE_PHN515_n_17 Z=n_93 VSS=DVSS VDD=DVDD
Xp96178A3141__6161 AO22D0 $PINS A1=FE_PHN194_bus_wbuf_50 A2=FE_PHN514_n_45
+ B1=FE_PHN4_bus_din_2 B2=FE_PHN515_n_17 Z=n_92 VSS=DVSS VDD=DVDD
Xp96178A3142__9315 AO22D0 $PINS A1=FE_PHN190_bus_wbuf_51 A2=FE_PHN514_n_45
+ B1=FE_PHN643_bus_din_3 B2=FE_PHN515_n_17 Z=n_91 VSS=DVSS VDD=DVDD
Xp96178A3143__9945 AO22D0 $PINS A1=FE_PHN180_bus_wbuf_52 A2=FE_PHN514_n_45
+ B1=FE_PHN626_bus_din_4 B2=FE_PHN515_n_17 Z=n_90 VSS=DVSS VDD=DVDD
Xp96178A3144__2883 AO22D0 $PINS A1=FE_PHN183_bus_wbuf_53 A2=FE_PHN514_n_45
+ B1=FE_PHN604_bus_din_5 B2=FE_PHN515_n_17 Z=n_89 VSS=DVSS VDD=DVDD
Xp96178A3145__2346 AO22D0 $PINS A1=FE_PHN200_bus_wbuf_54 A2=FE_PHN514_n_45
+ B1=FE_PHN625_bus_din_6 B2=FE_PHN515_n_17 Z=n_88 VSS=DVSS VDD=DVDD
Xp96178A3146__1666 AO22D0 $PINS A1=FE_PHN196_bus_wbuf_55 A2=FE_PHN514_n_45
+ B1=FE_PHN6_bus_din_7 B2=FE_PHN515_n_17 Z=n_87 VSS=DVSS VDD=DVDD
Xp96186A__7410 MOAI22D0 $PINS A1=n_101 A2=n_10 B1=FE_PHN228_bus_wbuf_56
+ B2=FE_PHN513_n_46 ZN=n_86 VSS=DVSS VDD=DVDD
Xp96186A3147__6417 MOAI22D0 $PINS A1=n_101 A2=n_9 B1=FE_PHN227_bus_wbuf_57
+ B2=FE_PHN513_n_46 ZN=n_85 VSS=DVSS VDD=DVDD
Xp96186A3148__5477 MOAI22D0 $PINS A1=n_101 A2=n_2 B1=FE_PHN226_bus_wbuf_58
+ B2=FE_PHN513_n_46 ZN=n_84 VSS=DVSS VDD=DVDD
Xp96186A3149__2398 MOAI22D0 $PINS A1=n_101 A2=FE_PHN651_n_4
+ B1=FE_PHN224_bus_wbuf_59 B2=FE_PHN513_n_46 ZN=n_83 VSS=DVSS VDD=DVDD
Xp96186A3150__5107 MOAI22D0 $PINS A1=n_101 A2=n_3 B1=FE_PHN221_bus_wbuf_60
+ B2=FE_PHN513_n_46 ZN=FE_PHN532_n_82 VSS=DVSS VDD=DVDD
Xp96186A3151__6260 MOAI22D0 $PINS A1=n_101 A2=n_1 B1=FE_PHN223_bus_wbuf_61
+ B2=FE_PHN513_n_46 ZN=FE_PHN533_n_81 VSS=DVSS VDD=DVDD
Xp96186A3152__4319 MOAI22D0 $PINS A1=n_101 A2=n_6 B1=FE_PHN222_bus_wbuf_62
+ B2=FE_PHN513_n_46 ZN=FE_PHN531_n_80 VSS=DVSS VDD=DVDD
Xp96186A3153__8428 MOAI22D0 $PINS A1=n_101 A2=n_5 B1=FE_PHN225_bus_wbuf_63
+ B2=FE_PHN513_n_46 ZN=n_79 VSS=DVSS VDD=DVDD
Xp96178A3154__5526 AO22D0 $PINS A1=FE_PHN186_bus_wbuf_24 A2=n_44
+ B1=FE_PHN622_bus_din_0 B2=n_18 Z=n_78 VSS=DVSS VDD=DVDD
Xp96178A3155__6783 AO22D0 $PINS A1=FE_PHN179_bus_wbuf_25 A2=n_44
+ B1=FE_PHN556_bus_din_1 B2=n_18 Z=n_77 VSS=DVSS VDD=DVDD
Xp96178A3156__3680 AO22D0 $PINS A1=FE_PHN182_bus_wbuf_26 A2=n_44
+ B1=FE_PHN4_bus_din_2 B2=n_18 Z=n_76 VSS=DVSS VDD=DVDD
Xp96178A3157__1617 AO22D0 $PINS A1=FE_PHN164_bus_wbuf_27 A2=n_44
+ B1=FE_PHN664_bus_din_3 B2=n_18 Z=n_75 VSS=DVSS VDD=DVDD
Xp96178A3158__2802 AO22D0 $PINS A1=FE_PHN165_bus_wbuf_28 A2=n_44
+ B1=FE_PHN559_bus_din_4 B2=n_18 Z=n_74 VSS=DVSS VDD=DVDD
Xp96178A3159__1705 AO22D0 $PINS A1=FE_PHN175_bus_wbuf_29 A2=n_44
+ B1=FE_PHN604_bus_din_5 B2=n_18 Z=n_73 VSS=DVSS VDD=DVDD
Xp96178A3160__5122 AO22D0 $PINS A1=FE_PHN172_bus_wbuf_30 A2=n_44
+ B1=FE_PHN649_bus_din_6 B2=n_18 Z=n_72 VSS=DVSS VDD=DVDD
Xp96178A3161__8246 AO22D0 $PINS A1=FE_PHN170_bus_wbuf_31 A2=n_44
+ B1=FE_PHN6_bus_din_7 B2=n_18 Z=n_71 VSS=DVSS VDD=DVDD
Xp96186A3162__7098 MOAI22D0 $PINS A1=n_27 A2=FE_PHN645_n_3
+ B1=FE_PHN161_bus_wbuf_36 B2=n_15 ZN=n_70 VSS=DVSS VDD=DVDD
Xp96186A3163__6131 MOAI22D0 $PINS A1=n_27 A2=FE_PHN651_n_4
+ B1=FE_PHN168_bus_wbuf_35 B2=n_15 ZN=n_69 VSS=DVSS VDD=DVDD
Xp96186A3164__1881 MOAI22D0 $PINS A1=n_27 A2=n_2 B1=FE_PHN173_bus_wbuf_34
+ B2=n_15 ZN=n_68 VSS=DVSS VDD=DVDD
Xp96186A3165__5115 MOAI22D0 $PINS A1=n_27 A2=n_1 B1=FE_PHN191_bus_wbuf_37
+ B2=n_15 ZN=n_67 VSS=DVSS VDD=DVDD
Xp96186A3182__7482 MOAI22D0 $PINS A1=n_27 A2=FE_PHN659_n_6
+ B1=FE_PHN189_bus_wbuf_38 B2=n_15 ZN=n_66 VSS=DVSS VDD=DVDD
Xp96186A3183__4733 MOAI22D0 $PINS A1=n_0 A2=n_10 B1=FE_PHN209_bus_wbuf_8
+ B2=n_16 ZN=n_65 VSS=DVSS VDD=DVDD
Xp96186A3184__6161 MOAI22D0 $PINS A1=n_27 A2=n_5 B1=FE_PHN181_bus_wbuf_39
+ B2=n_15 ZN=n_64 VSS=DVSS VDD=DVDD
Xp96178A3185__9315 AO22D0 $PINS A1=FE_PHN177_bus_wbuf_40 A2=n_26
+ B1=FE_PHN622_bus_din_0 B2=n_22 Z=n_63 VSS=DVSS VDD=DVDD
Xp96178A3186__9945 AO22D0 $PINS A1=FE_PHN176_bus_wbuf_41 A2=n_26
+ B1=FE_PHN616_bus_din_1 B2=n_22 Z=n_62 VSS=DVSS VDD=DVDD
Xp96178A3187__2883 AO22D0 $PINS A1=FE_PHN174_bus_wbuf_42 A2=n_26
+ B1=FE_PHN4_bus_din_2 B2=n_22 Z=n_61 VSS=DVSS VDD=DVDD
Xp96178A3188__2346 AO22D0 $PINS A1=FE_PHN166_bus_wbuf_43 A2=n_26
+ B1=FE_PHN643_bus_din_3 B2=n_22 Z=FE_PHN519_n_60 VSS=DVSS VDD=DVDD
Xp96186A3189__1666 MOAI22D0 $PINS A1=n_0 A2=n_9 B1=FE_PHN205_bus_wbuf_9 B2=n_16
+ ZN=n_59 VSS=DVSS VDD=DVDD
Xp96186A3190__7410 MOAI22D0 $PINS A1=n_0 A2=n_2 B1=FE_PHN199_bus_wbuf_10
+ B2=n_16 ZN=n_58 VSS=DVSS VDD=DVDD
Xp96178A3191__6417 AO22D0 $PINS A1=FE_PHN167_bus_wbuf_44 A2=n_26
+ B1=FE_PHN626_bus_din_4 B2=n_22 Z=FE_PHN522_n_57 VSS=DVSS VDD=DVDD
Xp96178A3192__5477 AO22D0 $PINS A1=FE_PHN171_bus_wbuf_45 A2=n_26
+ B1=FE_PHN604_bus_din_5 B2=n_22 Z=FE_PHN520_n_56 VSS=DVSS VDD=DVDD
Xp96186A3193__2398 MOAI22D0 $PINS A1=n_0 A2=FE_PHN650_n_4
+ B1=FE_PHN206_bus_wbuf_11 B2=n_16 ZN=n_55 VSS=DVSS VDD=DVDD
Xp96178A3194__5107 AO22D0 $PINS A1=FE_PHN178_bus_wbuf_46 A2=n_26
+ B1=FE_PHN625_bus_din_6 B2=n_22 Z=n_54 VSS=DVSS VDD=DVDD
Xp96178A3195__6260 AO22D0 $PINS A1=FE_PHN169_bus_wbuf_47 A2=n_26
+ B1=FE_PHN6_bus_din_7 B2=n_22 Z=n_53 VSS=DVSS VDD=DVDD
Xp96186A3196__4319 MOAI22D0 $PINS A1=n_0 A2=FE_PHN642_n_3
+ B1=FE_PHN204_bus_wbuf_12 B2=n_16 ZN=n_52 VSS=DVSS VDD=DVDD
Xp96186A3197__8428 MOAI22D0 $PINS A1=n_0 A2=n_1 B1=FE_PHN203_bus_wbuf_13
+ B2=n_16 ZN=n_51 VSS=DVSS VDD=DVDD
Xp96186A3198__5526 MOAI22D0 $PINS A1=n_0 A2=FE_PHN656_n_6
+ B1=FE_PHN202_bus_wbuf_14 B2=n_16 ZN=n_50 VSS=DVSS VDD=DVDD
Xp96186A3199__6783 MOAI22D0 $PINS A1=n_0 A2=n_5 B1=FE_PHN208_bus_wbuf_15
+ B2=n_16 ZN=n_49 VSS=DVSS VDD=DVDD
Xp96186A3200__3680 MOAI22D0 $PINS A1=n_27 A2=n_10 B1=FE_PHN195_bus_wbuf_32
+ B2=n_15 ZN=n_48 VSS=DVSS VDD=DVDD
Xp96186A3201__1617 MOAI22D0 $PINS A1=n_27 A2=n_9 B1=FE_PHN188_bus_wbuf_33
+ B2=n_15 ZN=n_47 VSS=DVSS VDD=DVDD
Xp96184A__2802 MOAI22D0 $PINS A1=n_20 A2=FE_PHN650_n_4 B1=FE_PHN215_bus_wbuf_3
+ B2=n_20 ZN=n_43 VSS=DVSS VDD=DVDD
Xp96184A3202__1705 MOAI22D0 $PINS A1=n_20 A2=n_2 B1=FE_PHN213_bus_wbuf_2
+ B2=n_20 ZN=n_42 VSS=DVSS VDD=DVDD
Xp96184A3203__5122 MOAI22D0 $PINS A1=n_20 A2=n_10 B1=FE_PHN212_bus_wbuf_0
+ B2=n_20 ZN=n_41 VSS=DVSS VDD=DVDD
Xp96184A3204__8246 MOAI22D0 $PINS A1=n_20 A2=n_5 B1=FE_PHN220_bus_wbuf_7
+ B2=n_20 ZN=n_40 VSS=DVSS VDD=DVDD
Xp96184A3205__7098 MOAI22D0 $PINS A1=n_20 A2=FE_PHN688_n_6
+ B1=FE_PHN219_bus_wbuf_6 B2=n_20 ZN=n_39 VSS=DVSS VDD=DVDD
Xp96184A3206__6131 MOAI22D0 $PINS A1=n_20 A2=n_9 B1=FE_PHN211_bus_wbuf_1
+ B2=n_20 ZN=n_38 VSS=DVSS VDD=DVDD
Xp96414A__1881 ND3D1 $PINS A1=n_19 A2=n_24 A3=FE_PHN620_bus_we ZN=n_46 VSS=DVSS
+ VDD=DVDD
Xp96435A__5115 ND2D1 $PINS A1=n_25 A2=FE_PHN620_bus_we ZN=n_45 VSS=DVSS
+ VDD=DVDD
Xp96414A3207__7482 IND3D0 $PINS A1=FE_PHN151_bus_addr_2 B1=FE_PHN620_bus_we
+ B2=n_19 ZN=n_44 VSS=DVSS VDD=DVDD
Xp96184A3208__4733 MOAI22D0 $PINS A1=n_20 A2=FE_PHN642_n_3
+ B1=FE_PHN216_bus_wbuf_4 B2=n_20 ZN=n_37 VSS=DVSS VDD=DVDD
Xp96184A3209__6161 MOAI22D0 $PINS A1=n_20 A2=n_1 B1=FE_PHN214_bus_wbuf_5
+ B2=n_20 ZN=n_36 VSS=DVSS VDD=DVDD
Xp96186A3210__9315 MOAI22D0 $PINS A1=n_23 A2=n_10 B1=FE_PHN197_bus_wbuf_16
+ B2=n_21 ZN=n_35 VSS=DVSS VDD=DVDD
Xp96186A3211__9945 MOAI22D1 $PINS A1=n_23 A2=n_9 B1=FE_PHN198_bus_wbuf_17
+ B2=n_21 ZN=n_34 VSS=DVSS VDD=DVDD
Xp96186A3212__2883 MOAI22D0 $PINS A1=n_23 A2=n_2 B1=FE_PHN201_bus_wbuf_18
+ B2=n_21 ZN=n_33 VSS=DVSS VDD=DVDD
Xp96186A3213__2346 MOAI22D1 $PINS A1=n_23 A2=n_4 B1=FE_PHN207_bus_wbuf_19
+ B2=n_21 ZN=n_32 VSS=DVSS VDD=DVDD
Xp96186A3214__1666 MOAI22D1 $PINS A1=n_23 A2=FE_PHN642_n_3
+ B1=FE_PHN192_bus_wbuf_20 B2=n_21 ZN=n_31 VSS=DVSS VDD=DVDD
Xp96186A3215__7410 MOAI22D1 $PINS A1=n_23 A2=n_1 B1=FE_PHN187_bus_wbuf_21
+ B2=n_21 ZN=FE_PHN527_n_30 VSS=DVSS VDD=DVDD
Xp96186A3216__6417 MOAI22D1 $PINS A1=n_23 A2=FE_PHN656_n_6
+ B1=FE_PHN184_bus_wbuf_22 B2=n_21 ZN=n_29 VSS=DVSS VDD=DVDD
Xp96186A3217__5477 MOAI22D0 $PINS A1=n_23 A2=n_5 B1=FE_PHN185_bus_wbuf_23
+ B2=n_21 ZN=n_28 VSS=DVSS VDD=DVDD
Xp96329A__2398 AOI221D0 $PINS A1=n_7 A2=FE_PHN151_bus_addr_2 B1=n_8
+ B2=FE_PHN152_bus_addr_1 C=FE_PHN150_bus_addr_0 ZN=n_25 VSS=DVSS VDD=DVDD
Xp96435A3230__5107 CKND2D0 $PINS A1=n_14 A2=FE_PHN151_bus_addr_2 ZN=n_27
+ VSS=DVSS VDD=DVDD
Xp96449A__6260 ND2D1 $PINS A1=n_24 A2=n_11 ZN=n_26 VSS=DVSS VDD=DVDD
Xp96397A__4319 IND2D0 $PINS A1=n_13 B1=n_102 ZN=n_24 VSS=DVSS VDD=DVDD
Xp96454A__8428 IND2D0 $PINS A1=n_103 B1=n_13 ZN=n_23 VSS=DVSS VDD=DVDD
Xp96416A__5526 NR2D1 $PINS A1=n_12 A2=n_102 ZN=n_22 VSS=DVSS VDD=DVDD
Xp96480A__6783 CKND2D0 $PINS A1=n_13 A2=FE_PHN620_bus_we ZN=n_21 VSS=DVSS
+ VDD=DVDD
Xp96407A__3680 ND2D1 $PINS A1=n_11 A2=n_13 ZN=n_20 VSS=DVSS VDD=DVDD
XFp96438A CKND0 $PINS I=n_14 ZN=n_15 VSS=DVSS VDD=DVDD
Xp96389A__1617 MUX2ND0 $PINS I0=FE_PHN152_bus_addr_1 I1=n_7
+ S=FE_PHN150_bus_addr_0 ZN=n_19 VSS=DVSS VDD=DVDD
Xp96369A__2802 INR3D0 $PINS A1=FE_PHN150_bus_addr_0 B1=FE_PHN151_bus_addr_2
+ B2=n_103 ZN=FE_PHN516_n_18 VSS=DVSS VDD=DVDD
Xp96380A__1705 NR3D1 $PINS A1=n_103 A2=n_8 A3=FE_PHN150_bus_addr_0 ZN=n_17
+ VSS=DVSS VDD=DVDD
Xp96372A__5122 CKND2D0 $PINS A1=n_11 A2=n_8 ZN=n_16 VSS=DVSS VDD=DVDD
Xp96418A__8246 NR2D0 $PINS A1=n_12 A2=FE_PHN150_bus_addr_0 ZN=n_14 VSS=DVSS
+ VDD=DVDD
Xp96346A__7098 NR2D0 $PINS A1=FE_PHN151_bus_addr_2 A2=FE_PHN150_bus_addr_0
+ ZN=n_13 VSS=DVSS VDD=DVDD
XFp96342A CKND0 $PINS I=n_12 ZN=n_11 VSS=DVSS VDD=DVDD
Xp96329A3232__6131 CKND2D0 $PINS A1=n_7 A2=FE_PHN620_bus_we ZN=FE_PHN507_n_12
+ VSS=DVSS VDD=DVDD
XFp96541A INVD1 $PINS I=FE_PHN622_bus_din_0 ZN=n_10 VSS=DVSS VDD=DVDD
XFp96541A3233 INVD1 $PINS I=FE_PHN616_bus_din_1 ZN=n_9 VSS=DVSS VDD=DVDD
XFp96333A CKND0 $PINS I=FE_PHN151_bus_addr_2 ZN=n_8 VSS=DVSS VDD=DVDD
XFp96314A CKND0 $PINS I=FE_PHN152_bus_addr_1 ZN=n_7 VSS=DVSS VDD=DVDD
XFp96541A3234 INVD1 $PINS I=FE_PHN625_bus_din_6 ZN=FE_PHN663_n_6 VSS=DVSS
+ VDD=DVDD
XFp96541A3235 CKND1 $PINS I=FE_PHN6_bus_din_7 ZN=n_5 VSS=DVSS VDD=DVDD
XFp96541A3236 INVD2 $PINS I=FE_PHN635_bus_din_3 ZN=FE_PHN627_n_4 VSS=DVSS
+ VDD=DVDD
XFp96541A3237 INVD1 $PINS I=FE_PHN626_bus_din_4 ZN=FE_PHN638_n_3 VSS=DVSS
+ VDD=DVDD
XFp96541A3238 INVD1 $PINS I=FE_PHN639_bus_din_2 ZN=n_2 VSS=DVSS VDD=DVDD
XFp96541A3239 INVD1 $PINS I=FE_PHN604_bus_din_5 ZN=FE_PHN574_n_1 VSS=DVSS
+ VDD=DVDD
Xg2205__1881 IND2D0 $PINS A1=n_16 B1=FE_PHN150_bus_addr_0 ZN=n_0 VSS=DVSS
+ VDD=DVDD
XFILLER_T_4_135 DCAP8 $PINS VSS=DVSS VDD=DVDD
XFILLER_T_4_131 DCAP8 $PINS VSS=DVSS VDD=DVDD
XFILLER_T_4_130 DCAP4 $PINS VSS=DVSS VDD=DVDD
XFILLER_T_4_116 DCAP4 $PINS VSS=DVSS VDD=DVDD
XFILLER_T_4_87 DCAP4 $PINS VSS=DVSS VDD=DVDD
XFILLER_T_4_85 DCAP4 $PINS VSS=DVSS VDD=DVDD
XFILLER_T_4_83 DCAP4 $PINS VSS=DVSS VDD=DVDD
XFILLER_T_5_101 DCAP16 $PINS VSS=DVSS VDD=DVDD
XFILLER_T_5_100 DCAP32 $PINS VSS=DVSS VDD=DVDD
XFILLER_T_5_99 DCAP4 $PINS VSS=DVSS VDD=DVDD
XFILLER_T_5_98 DCAP16 $PINS VSS=DVSS VDD=DVDD
XFILLER_T_5_96 DCAP8 $PINS VSS=DVSS VDD=DVDD
XFILLER_T_5_95 DCAP64 $PINS VSS=DVSS VDD=DVDD
XFILLER_T_5_92 DCAP8 $PINS VSS=DVSS VDD=DVDD
XFILLER_T_5_91 DCAP32 $PINS VSS=DVSS VDD=DVDD
XFILLER_T_5_86 DCAP4 $PINS VSS=DVSS VDD=DVDD
XFILLER_T_5_84 DCAP8 $PINS VSS=DVSS VDD=DVDD
XFILLER_T_5_83 DCAP64 $PINS VSS=DVSS VDD=DVDD
XFILLER_T_5_81 DCAP8 $PINS VSS=DVSS VDD=DVDD
XFILLER_T_5_80 DCAP64 $PINS VSS=DVSS VDD=DVDD
XFILLER_T_5_78 DCAP8 $PINS VSS=DVSS VDD=DVDD
XFILLER_T_5_77 DCAP64 $PINS VSS=DVSS VDD=DVDD
XFILLER_T_5_75 DCAP8 $PINS VSS=DVSS VDD=DVDD
XFILLER_T_5_74 DCAP64 $PINS VSS=DVSS VDD=DVDD
XFILLER_T_4_65 DCAP4 $PINS VSS=DVSS VDD=DVDD
XFILLER_T_5_71 DCAP4 $PINS VSS=DVSS VDD=DVDD
XFILLER_T_5_70 DCAP32 $PINS VSS=DVSS VDD=DVDD
XFILLER_T_5_68 DCAP4 $PINS VSS=DVSS VDD=DVDD
XFILLER_T_5_67 DCAP8 $PINS VSS=DVSS VDD=DVDD
XFILLER_T_5_66 DCAP16 $PINS VSS=DVSS VDD=DVDD
XFILLER_T_4_61 DCAP4 $PINS VSS=DVSS VDD=DVDD
XFILLER_T_5_63 DCAP8 $PINS VSS=DVSS VDD=DVDD
XFILLER_T_5_62 DCAP16 $PINS VSS=DVSS VDD=DVDD
XFILLER_T_5_61 DCAP32 $PINS VSS=DVSS VDD=DVDD
XFILLER_T_4_58 DCAP4 $PINS VSS=DVSS VDD=DVDD
XFILLER_T_5_57 DCAP16 $PINS VSS=DVSS VDD=DVDD
XFILLER_T_5_56 DCAP32 $PINS VSS=DVSS VDD=DVDD
XFILLER_T_5_54 DCAP8 $PINS VSS=DVSS VDD=DVDD
XFILLER_T_5_53 DCAP64 $PINS VSS=DVSS VDD=DVDD
XFILLER_T_5_51 DCAP8 $PINS VSS=DVSS VDD=DVDD
XFILLER_T_5_50 DCAP64 $PINS VSS=DVSS VDD=DVDD
XFILLER_T_5_45 DCAP16 $PINS VSS=DVSS VDD=DVDD
XFILLER_T_5_41 DCAP4 $PINS VSS=DVSS VDD=DVDD
XFILLER_T_5_40 DCAP8 $PINS VSS=DVSS VDD=DVDD
XFILLER_T_5_39 DCAP16 $PINS VSS=DVSS VDD=DVDD
XFILLER_T_5_36 DCAP16 $PINS VSS=DVSS VDD=DVDD
XFILLER_T_5_28 DCAP16 $PINS VSS=DVSS VDD=DVDD
XFILLER_T_5_27 DCAP32 $PINS VSS=DVSS VDD=DVDD
XFILLER_T_5_22 DCAP16 $PINS VSS=DVSS VDD=DVDD
XFILLER_T_5_17 DCAP16 $PINS VSS=DVSS VDD=DVDD
XFILLER_T_5_16 DCAP32 $PINS VSS=DVSS VDD=DVDD
XFILLER_T_5_12 DCAP16 $PINS VSS=DVSS VDD=DVDD
XFILLER_T_5_11 DCAP32 $PINS VSS=DVSS VDD=DVDD
XFILLER_T_4_9 DCAP4 $PINS VSS=DVSS VDD=DVDD
XFILLER_T_5_5 DCAP32 $PINS VSS=DVSS VDD=DVDD
XFILLER_T_5_3 DCAP4 $PINS VSS=DVSS VDD=DVDD
XFILLER_T_4_6 DCAP4 $PINS VSS=DVSS VDD=DVDD
XFILLER_T_5_1 DCAP16 $PINS VSS=DVSS VDD=DVDD
XFILLER_T_4_2 DCAP4 $PINS VSS=DVSS VDD=DVDD
XFILLER_T_2_226 DCAP16 $PINS VSS=DVSS VDD=DVDD
XFILLER_T_2_220 DCAP4 $PINS VSS=DVSS VDD=DVDD
XFILLER_T_2_217 DCAP4 $PINS VSS=DVSS VDD=DVDD
XFILLER_T_2_212 DCAP4 $PINS VSS=DVSS VDD=DVDD
XFILLER_T_2_211 DCAP8 $PINS VSS=DVSS VDD=DVDD
XFILLER_T_2_210 DCAP4 $PINS VSS=DVSS VDD=DVDD
XFILLER_T_2_206 DCAP8 $PINS VSS=DVSS VDD=DVDD
XFILLER_T_2_205 DCAP4 $PINS VSS=DVSS VDD=DVDD
XFILLER_T_2_201 DCAP8 $PINS VSS=DVSS VDD=DVDD
XFILLER_T_2_194 DCAP8 $PINS VSS=DVSS VDD=DVDD
XFILLER_T_2_190 DCAP4 $PINS VSS=DVSS VDD=DVDD
XFILLER_T_2_188 DCAP4 $PINS VSS=DVSS VDD=DVDD
XFILLER_T_2_180 DCAP8 $PINS VSS=DVSS VDD=DVDD
XFILLER_T_2_178 DCAP4 $PINS VSS=DVSS VDD=DVDD
XFILLER_T_2_174 DCAP4 $PINS VSS=DVSS VDD=DVDD
XFILLER_T_2_170 DCAP4 $PINS VSS=DVSS VDD=DVDD
XFILLER_T_2_168 DCAP4 $PINS VSS=DVSS VDD=DVDD
XFILLER_T_2_167 DCAP8 $PINS VSS=DVSS VDD=DVDD
XFILLER_T_2_158 DCAP4 $PINS VSS=DVSS VDD=DVDD
XFILLER_T_2_149 DCAP4 $PINS VSS=DVSS VDD=DVDD
XFILLER_T_2_145 DCAP4 $PINS VSS=DVSS VDD=DVDD
XFILLER_T_1_130 DCAP8 $PINS VSS=DVSS VDD=DVDD
XFILLER_T_1_126 DCAP8 $PINS VSS=DVSS VDD=DVDD
XFILLER_T_2_115 DCAP8 $PINS VSS=DVSS VDD=DVDD
XFILLER_T_2_113 DCAP4 $PINS VSS=DVSS VDD=DVDD
XFILLER_T_2_109 DCAP4 $PINS VSS=DVSS VDD=DVDD
XFILLER_T_2_102 DCAP4 $PINS VSS=DVSS VDD=DVDD
XFILLER_T_1_100 DCAP4 $PINS VSS=DVSS VDD=DVDD
XFILLER_T_1_99 DCAP8 $PINS VSS=DVSS VDD=DVDD
XFILLER_T_2_90 DCAP4 $PINS VSS=DVSS VDD=DVDD
XFILLER_T_2_86 DCAP4 $PINS VSS=DVSS VDD=DVDD
XFILLER_T_2_82 DCAP4 $PINS VSS=DVSS VDD=DVDD
XFILLER_T_2_81 DCAP4 $PINS VSS=DVSS VDD=DVDD
XFILLER_T_2_78 DCAP4 $PINS VSS=DVSS VDD=DVDD
XFILLER_T_1_79 DCAP4 $PINS VSS=DVSS VDD=DVDD
XFILLER_T_2_75 DCAP4 $PINS VSS=DVSS VDD=DVDD
XFILLER_T_2_73 DCAP8 $PINS VSS=DVSS VDD=DVDD
XFILLER_T_2_72 DCAP8 $PINS VSS=DVSS VDD=DVDD
XFILLER_T_2_48 DCAP4 $PINS VSS=DVSS VDD=DVDD
XFILLER_T_2_45 DCAP4 $PINS VSS=DVSS VDD=DVDD
XFILLER_T_2_39 DCAP4 $PINS VSS=DVSS VDD=DVDD
XFILLER_T_2_31 DCAP4 $PINS VSS=DVSS VDD=DVDD
XFILLER_T_2_30 DCAP8 $PINS VSS=DVSS VDD=DVDD
XFILLER_T_2_29 DCAP8 $PINS VSS=DVSS VDD=DVDD
XFILLER_T_2_25 DCAP4 $PINS VSS=DVSS VDD=DVDD
XFILLER_T_2_23 DCAP8 $PINS VSS=DVSS VDD=DVDD
XFILLER_T_2_21 DCAP8 $PINS VSS=DVSS VDD=DVDD
XFILLER_T_2_20 DCAP8 $PINS VSS=DVSS VDD=DVDD
XFILLER_T_2_15 DCAP4 $PINS VSS=DVSS VDD=DVDD
XFILLER_T_2_10 DCAP8 $PINS VSS=DVSS VDD=DVDD
XFILLER_T_1_7 DCAP8 $PINS VSS=DVSS VDD=DVDD
XFILLER_T_2_7 DCAP4 $PINS VSS=DVSS VDD=DVDD
XFILLER_T_2_1 DCAP4 $PINS VSS=DVSS VDD=DVDD
.ENDS
.GLOBAL DVDD
.GLOBAL DVSS
