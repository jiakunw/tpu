$ Spice netlist generated by v2lvs
$ v2024.3_25.13    Thu Aug 1 18:56:55 PDT 2024
.INCLUDE "/courses/ee6350/pdk2023/T-N65-CM-SP-018-K3_MOM/digital/Back_End/spice/tcbn65gplus_200a/tcbn65gplus_200a.spi"
.INCLUDE "../../../SRAM00_gen/sram00.cdl"
*.BUSDELIMITER <

.SUBCKT sram_wrapper clk rstn bus_we bus_addr<11> bus_addr<10> bus_addr<9>
+ bus_addr<8> bus_addr<7> bus_addr<6> bus_addr<5> bus_addr<4> bus_addr<3>
+ bus_addr<2> bus_addr<1> bus_addr<0> bus_din<7> bus_din<6> bus_din<5>
+ bus_din<4> bus_din<3> bus_din<2> bus_din<1> bus_din<0> tpu_re tpu_addr<8>
+ tpu_addr<7> tpu_addr<6> tpu_addr<5> tpu_addr<4> tpu_addr<3> tpu_addr<2>
+ tpu_addr<1> tpu_addr<0> tpu_dout<63> tpu_dout<62> tpu_dout<61> tpu_dout<60>
+ tpu_dout<59> tpu_dout<58> tpu_dout<57> tpu_dout<56> tpu_dout<55> tpu_dout<54>
+ tpu_dout<53> tpu_dout<52> tpu_dout<51> tpu_dout<50> tpu_dout<49> tpu_dout<48>
+ tpu_dout<47> tpu_dout<46> tpu_dout<45> tpu_dout<44> tpu_dout<43> tpu_dout<42>
+ tpu_dout<41> tpu_dout<40> tpu_dout<39> tpu_dout<38> tpu_dout<37> tpu_dout<36>
+ tpu_dout<35> tpu_dout<34> tpu_dout<33> tpu_dout<32> tpu_dout<31> tpu_dout<30>
+ tpu_dout<29> tpu_dout<28> tpu_dout<27> tpu_dout<26> tpu_dout<25> tpu_dout<24>
+ tpu_dout<23> tpu_dout<22> tpu_dout<21> tpu_dout<20> tpu_dout<19> tpu_dout<18>
+ tpu_dout<17> tpu_dout<16> tpu_dout<15> tpu_dout<14> tpu_dout<13> tpu_dout<12>
+ tpu_dout<11> tpu_dout<10> tpu_dout<9> tpu_dout<8> tpu_dout<7> tpu_dout<6>
+ tpu_dout<5> tpu_dout<4> tpu_dout<3> tpu_dout<2> tpu_dout<1> tpu_dout<0> DVDD
+ DVSS
XFE_PDC542_tpu_dout_58 BUFFD8 $PINS I=FE_PDN541_tpu_dout_58 Z=tpu_dout<58>
+ VSS=DVSS VDD=DVDD
XFE_PDC540_tpu_dout_54 BUFFD8 $PINS I=FE_PDN539_tpu_dout_54 Z=tpu_dout<54>
+ VSS=DVSS VDD=DVDD
XFE_PHC538_bus_din_5 BUFFD1 $PINS I=FE_PHN537_bus_din_5 Z=FE_PHN538_bus_din_5
+ VSS=DVSS VDD=DVDD
XFE_PHC537_bus_din_5 DEL005 $PINS I=FE_PHN178_bus_din_5 Z=FE_PHN537_bus_din_5
+ VSS=DVSS VDD=DVDD
XFE_PHC536_bus_din_5 CKBD0 $PINS I=FE_PHN536_bus_din_5 Z=FE_PHN534_bus_din_5
+ VSS=DVSS VDD=DVDD
XFE_PHC535_bus_din_5 CKBD0 $PINS I=FE_PHN535_bus_din_5 Z=FE_PHN533_bus_din_5
+ VSS=DVSS VDD=DVDD
XFE_PHC534_bus_din_5 CKBD0 $PINS I=FE_PHN534_bus_din_5 Z=FE_PHN532_bus_din_5
+ VSS=DVSS VDD=DVDD
XFE_PHC533_bus_din_5 CKBD0 $PINS I=FE_PHN533_bus_din_5 Z=FE_PHN531_bus_din_5
+ VSS=DVSS VDD=DVDD
XFE_PHC532_bus_din_5 CKBD0 $PINS I=FE_PHN532_bus_din_5 Z=FE_PHN530_bus_din_5
+ VSS=DVSS VDD=DVDD
XFE_PHC531_bus_din_5 CKBD0 $PINS I=FE_PHN531_bus_din_5 Z=FE_PHN529_bus_din_5
+ VSS=DVSS VDD=DVDD
XFE_PHC530_bus_din_5 CKBD0 $PINS I=FE_PHN530_bus_din_5 Z=FE_PHN527_bus_din_5
+ VSS=DVSS VDD=DVDD
XFE_PHC529_bus_din_5 CKBD0 $PINS I=FE_PHN529_bus_din_5 Z=FE_PHN528_bus_din_5
+ VSS=DVSS VDD=DVDD
XFE_PHC528_bus_din_5 CKBD0 $PINS I=FE_PHN528_bus_din_5 Z=FE_PHN409_bus_din_5
+ VSS=DVSS VDD=DVDD
XFE_PHC527_bus_din_5 CKBD0 $PINS I=FE_PHN527_bus_din_5 Z=FE_PHN513_bus_din_5
+ VSS=DVSS VDD=DVDD
XFE_PHC526_bus_din_3 CKBD1 $PINS I=FE_PHN445_bus_din_3 Z=FE_PHN526_bus_din_3
+ VSS=DVSS VDD=DVDD
XFE_PHC525_bus_din_5 DEL0 $PINS I=FE_PHN516_bus_din_5 Z=FE_PHN525_bus_din_5
+ VSS=DVSS VDD=DVDD
XFE_PHC524_bus_din_5 CKBD0 $PINS I=FE_PHN178_bus_din_5 Z=FE_PHN524_bus_din_5
+ VSS=DVSS VDD=DVDD
XFE_PHC523_bus_din_3 CKBD0 $PINS I=FE_PHN523_bus_din_3 Z=FE_PHN520_bus_din_3
+ VSS=DVSS VDD=DVDD
XFE_PHC522_bus_din_5 DEL0 $PINS I=FE_PHN516_bus_din_5 Z=FE_PHN522_bus_din_5
+ VSS=DVSS VDD=DVDD
XFE_PHC521_bus_din_5 CKBD0 $PINS I=FE_PHN178_bus_din_5 Z=FE_PHN521_bus_din_5
+ VSS=DVSS VDD=DVDD
XFE_PHC520_bus_din_3 DEL005 $PINS I=FE_PHN520_bus_din_3 Z=FE_PHN472_bus_din_3
+ VSS=DVSS VDD=DVDD
XFE_PHC519_bus_din_1 CKBD1 $PINS I=FE_PHN512_bus_din_1 Z=FE_PHN519_bus_din_1
+ VSS=DVSS VDD=DVDD
XFE_PHC518_bus_din_3 DEL005 $PINS I=FE_PHN501_bus_din_3 Z=FE_PHN518_bus_din_3
+ VSS=DVSS VDD=DVDD
XFE_PHC517_bus_din_0 BUFFD1 $PINS I=FE_PHN509_bus_din_0 Z=FE_PHN517_bus_din_0
+ VSS=DVSS VDD=DVDD
XFE_PHC516_bus_din_5 DEL0 $PINS I=FE_PHN524_bus_din_5 Z=FE_PHN516_bus_din_5
+ VSS=DVSS VDD=DVDD
XFE_PHC515_bus_din_4 DEL015 $PINS I=FE_PHN515_bus_din_4 Z=FE_PHN435_bus_din_4
+ VSS=DVSS VDD=DVDD
XFE_PHC514_bus_addr_2 CKBD1 $PINS I=bus_addr<2> Z=FE_PHN514_bus_addr_2 VSS=DVSS
+ VDD=DVDD
XFE_PHC513_bus_din_5 CKBD1 $PINS I=FE_PHN513_bus_din_5 Z=FE_PHN178_bus_din_5
+ VSS=DVSS VDD=DVDD
XFE_PHC512_bus_din_1 DEL005 $PINS I=FE_PHN490_bus_din_1 Z=FE_PHN512_bus_din_1
+ VSS=DVSS VDD=DVDD
XFE_PHC511_bus_din_2 BUFFD1 $PINS I=FE_PHN471_bus_din_2 Z=FE_PHN511_bus_din_2
+ VSS=DVSS VDD=DVDD
XFE_PHC510_bus_din_7 DEL01 $PINS I=FE_PHN433_bus_din_7 Z=FE_PHN510_bus_din_7
+ VSS=DVSS VDD=DVDD
XFE_PHC509_bus_din_0 DEL01 $PINS I=FE_PHN454_bus_din_0 Z=FE_PHN509_bus_din_0
+ VSS=DVSS VDD=DVDD
XFE_PHC508_bus_din_0 BUFFD1 $PINS I=FE_PHN507_bus_din_0 Z=FE_PHN508_bus_din_0
+ VSS=DVSS VDD=DVDD
XFE_PHC507_bus_din_0 CKBD0 $PINS I=FE_PHN506_bus_din_0 Z=FE_PHN507_bus_din_0
+ VSS=DVSS VDD=DVDD
XFE_PHC506_bus_din_0 CKBD0 $PINS I=FE_PHN473_bus_din_0 Z=FE_PHN506_bus_din_0
+ VSS=DVSS VDD=DVDD
XFE_PHC505_bus_din_0 CKBD1 $PINS I=FE_PHN439_bus_din_0 Z=FE_PHN505_bus_din_0
+ VSS=DVSS VDD=DVDD
XFE_PHC504_bus_din_0 DEL005 $PINS I=FE_PHN503_bus_din_0 Z=FE_PHN504_bus_din_0
+ VSS=DVSS VDD=DVDD
XFE_PHC503_bus_din_0 DEL005 $PINS I=FE_PHN502_bus_din_0 Z=FE_PHN503_bus_din_0
+ VSS=DVSS VDD=DVDD
XFE_PHC502_bus_din_0 CKBD0 $PINS I=FE_PHN504_bus_din_0 Z=FE_PHN498_bus_din_0
+ VSS=DVSS VDD=DVDD
XFE_PHC501_bus_din_3 CKBD0 $PINS I=FE_PHN518_bus_din_3 Z=FE_PHN499_bus_din_3
+ VSS=DVSS VDD=DVDD
XFE_PHC500_bus_din_0 DEL005 $PINS I=FE_PHN500_bus_din_0 Z=FE_PHN502_bus_din_0
+ VSS=DVSS VDD=DVDD
XFE_PHC499_bus_din_3 CKBD0 $PINS I=FE_PHN499_bus_din_3 Z=FE_PHN497_bus_din_3
+ VSS=DVSS VDD=DVDD
XFE_PHC498_bus_din_0 CKBD0 $PINS I=FE_PHN498_bus_din_0 Z=FE_PHN495_bus_din_0
+ VSS=DVSS VDD=DVDD
XFE_PHC497_bus_din_3 CKBD0 $PINS I=FE_PHN497_bus_din_3 Z=FE_PHN494_bus_din_3
+ VSS=DVSS VDD=DVDD
XFE_PHC496_bus_din_6 CKBD1 $PINS I=FE_PHN493_bus_din_6 Z=FE_PHN496_bus_din_6
+ VSS=DVSS VDD=DVDD
XFE_PHC495_bus_din_0 DEL005 $PINS I=FE_PHN495_bus_din_0 Z=FE_PHN488_bus_din_0
+ VSS=DVSS VDD=DVDD
XFE_PHC494_bus_din_3 CKBD0 $PINS I=FE_PHN494_bus_din_3 Z=FE_PHN491_bus_din_3
+ VSS=DVSS VDD=DVDD
XFE_PHC493_bus_din_6 DEL005 $PINS I=FE_PHN460_bus_din_6 Z=FE_PHN493_bus_din_6
+ VSS=DVSS VDD=DVDD
XFE_PHC492_bus_din_0 DEL005 $PINS I=FE_PHN492_bus_din_0 Z=FE_PHN500_bus_din_0
+ VSS=DVSS VDD=DVDD
XFE_PHC491_bus_din_3 CKBD0 $PINS I=FE_PHN491_bus_din_3 Z=FE_PHN487_bus_din_3
+ VSS=DVSS VDD=DVDD
XFE_PHC490_bus_din_1 DEL005 $PINS I=FE_PHN485_bus_din_1 Z=FE_PHN490_bus_din_1
+ VSS=DVSS VDD=DVDD
XFE_PHC489_bus_din_6 CKBD0 $PINS I=FE_PHN489_bus_din_6 Z=FE_PHN180_bus_din_6
+ VSS=DVSS VDD=DVDD
XFE_PHC488_bus_din_0 CKBD0 $PINS I=FE_PHN488_bus_din_0 Z=FE_PHN483_bus_din_0
+ VSS=DVSS VDD=DVDD
XFE_PHC487_bus_din_3 CKBD0 $PINS I=FE_PHN487_bus_din_3 Z=FE_PHN484_bus_din_3
+ VSS=DVSS VDD=DVDD
XFE_PHC486_bus_din_6 CKBD0 $PINS I=FE_PHN180_bus_din_6 Z=FE_PHN486_bus_din_6
+ VSS=DVSS VDD=DVDD
XFE_PHC485_bus_din_1 CKBD0 $PINS I=FE_PHN519_bus_din_1 Z=FE_PHN478_bus_din_1
+ VSS=DVSS VDD=DVDD
XFE_PHC484_bus_din_3 CKBD0 $PINS I=FE_PHN484_bus_din_3 Z=FE_PHN479_bus_din_3
+ VSS=DVSS VDD=DVDD
XFE_PHC483_bus_din_0 CKBD0 $PINS I=FE_PHN465_bus_din_0 Z=FE_PHN492_bus_din_0
+ VSS=DVSS VDD=DVDD
XFE_PHC482_bus_din_1 DEL005 $PINS I=FE_PHN482_bus_din_1 Z=FE_PHN485_bus_din_1
+ VSS=DVSS VDD=DVDD
XFE_PHC481_bus_din_6 CKBD0 $PINS I=FE_PHN486_bus_din_6 Z=FE_PHN481_bus_din_6
+ VSS=DVSS VDD=DVDD
XFE_PHC480_bus_din_0 CKBD0 $PINS I=FE_PHN432_bus_din_0 Z=FE_PHN480_bus_din_0
+ VSS=DVSS VDD=DVDD
XFE_PHC479_bus_din_3 CKBD0 $PINS I=FE_PHN479_bus_din_3 Z=FE_PHN523_bus_din_3
+ VSS=DVSS VDD=DVDD
XFE_PHC478_bus_din_1 DEL005 $PINS I=FE_PHN474_bus_din_1 Z=FE_PHN482_bus_din_1
+ VSS=DVSS VDD=DVDD
XFE_PHC477_bus_din_6 DEL005 $PINS I=FE_PHN481_bus_din_6 Z=FE_PHN477_bus_din_6
+ VSS=DVSS VDD=DVDD
XFE_PHC476_bus_din_4 CKBD1 $PINS I=FE_PHN476_bus_din_4 Z=FE_PHN470_bus_din_4
+ VSS=DVSS VDD=DVDD
XFE_PHC475_bus_din_6 CKBD0 $PINS I=FE_PHN434_bus_din_6 Z=FE_PHN475_bus_din_6
+ VSS=DVSS VDD=DVDD
XFE_PHC474_bus_din_1 CKBD0 $PINS I=FE_PHN478_bus_din_1 Z=FE_PHN467_bus_din_1
+ VSS=DVSS VDD=DVDD
XFE_PHC473_bus_din_0 DEL005 $PINS I=FE_PHN432_bus_din_0 Z=FE_PHN473_bus_din_0
+ VSS=DVSS VDD=DVDD
XFE_PHC472_bus_din_3 CKBD0 $PINS I=FE_PHN472_bus_din_3 Z=FE_PHN468_bus_din_3
+ VSS=DVSS VDD=DVDD
XFE_PHC471_bus_din_2 CKBD1 $PINS I=bus_din<2> Z=FE_PHN471_bus_din_2 VSS=DVSS
+ VDD=DVDD
XFE_PHC470_bus_din_4 DEL01 $PINS I=FE_PHN470_bus_din_4 Z=FE_PHN464_bus_din_4
+ VSS=DVSS VDD=DVDD
XFE_PHC469_bus_din_6 CKBD0 $PINS I=FE_PHN475_bus_din_6 Z=FE_PHN469_bus_din_6
+ VSS=DVSS VDD=DVDD
XFE_PHC468_bus_din_3 DEL005 $PINS I=FE_PHN468_bus_din_3 Z=FE_PHN421_bus_din_3
+ VSS=DVSS VDD=DVDD
XFE_PHC467_bus_din_1 DEL005 $PINS I=FE_PHN461_bus_din_1 Z=FE_PHN474_bus_din_1
+ VSS=DVSS VDD=DVDD
XFE_PHC466_bus_din_2 DEL005 $PINS I=FE_PHN466_bus_din_2 Z=FE_PHN463_bus_din_2
+ VSS=DVSS VDD=DVDD
XFE_PHC465_bus_din_0 CKBD0 $PINS I=FE_PHN424_bus_din_0 Z=FE_PHN465_bus_din_0
+ VSS=DVSS VDD=DVDD
XFE_PHC464_bus_din_4 CKBD0 $PINS I=FE_PHN464_bus_din_4 Z=FE_PHN459_bus_din_4
+ VSS=DVSS VDD=DVDD
XFE_PHC463_bus_din_2 DEL005 $PINS I=FE_PHN447_bus_din_2 Z=FE_PHN466_bus_din_2
+ VSS=DVSS VDD=DVDD
XFE_PHC462_bus_din_0 CKBD0 $PINS I=FE_PHN483_bus_din_0 Z=FE_PHN462_bus_din_0
+ VSS=DVSS VDD=DVDD
XFE_PHC461_bus_din_1 CKBD0 $PINS I=FE_PHN429_bus_din_1 Z=FE_PHN461_bus_din_1
+ VSS=DVSS VDD=DVDD
XFE_PHC460_bus_din_6 DEL005 $PINS I=FE_PHN434_bus_din_6 Z=FE_PHN460_bus_din_6
+ VSS=DVSS VDD=DVDD
XFE_PHC459_bus_din_4 DEL01 $PINS I=FE_PHN459_bus_din_4 Z=FE_PHN452_bus_din_4
+ VSS=DVSS VDD=DVDD
XFE_PHC458_bus_din_1 CKBD1 $PINS I=FE_PHN451_bus_din_1 Z=FE_PHN458_bus_din_1
+ VSS=DVSS VDD=DVDD
XFE_PHC457_bus_din_6 CKBD0 $PINS I=FE_PHN469_bus_din_6 Z=FE_PHN457_bus_din_6
+ VSS=DVSS VDD=DVDD
XFE_PHC456_bus_din_3 DEL0 $PINS I=FE_PHN174_bus_din_3 Z=FE_PHN456_bus_din_3
+ VSS=DVSS VDD=DVDD
XFE_PHC455_bus_din_1 DEL005 $PINS I=FE_PHN412_bus_din_1 Z=FE_PHN455_bus_din_1
+ VSS=DVSS VDD=DVDD
XFE_PHC454_bus_din_0 CKBD0 $PINS I=FE_PHN462_bus_din_0 Z=FE_PHN454_bus_din_0
+ VSS=DVSS VDD=DVDD
XFE_PHC453_bus_din_2 DEL015 $PINS I=FE_PHN511_bus_din_2 Z=FE_PHN453_bus_din_2
+ VSS=DVSS VDD=DVDD
XFE_PHC452_bus_din_4 CKBD0 $PINS I=FE_PHN452_bus_din_4 Z=FE_PHN446_bus_din_4
+ VSS=DVSS VDD=DVDD
XFE_PHC451_bus_din_1 CKBD1 $PINS I=FE_PHN443_bus_din_1 Z=FE_PHN451_bus_din_1
+ VSS=DVSS VDD=DVDD
XFE_PHC450_bus_din_2 DEL01 $PINS I=FE_PHN442_bus_din_2 Z=FE_PHN450_bus_din_2
+ VSS=DVSS VDD=DVDD
XFE_PHC449_bus_din_0 CKBD0 $PINS I=FE_PHN517_bus_din_0 Z=FE_PHN449_bus_din_0
+ VSS=DVSS VDD=DVDD
XFE_PHC448_bus_din_1 CKBD0 $PINS I=FE_PHN455_bus_din_1 Z=FE_PHN448_bus_din_1
+ VSS=DVSS VDD=DVDD
XFE_PHC447_bus_din_2 DEL005 $PINS I=FE_PHN453_bus_din_2 Z=FE_PHN447_bus_din_2
+ VSS=DVSS VDD=DVDD
XFE_PHC446_bus_din_4 DEL015 $PINS I=FE_PHN446_bus_din_4 Z=FE_PHN515_bus_din_4
+ VSS=DVSS VDD=DVDD
XFE_PHC445_bus_din_3 DEL015 $PINS I=FE_PHN174_bus_din_3 Z=FE_PHN445_bus_din_3
+ VSS=DVSS VDD=DVDD
XFE_PHC444_bus_din_6 DEL0 $PINS I=FE_PHN434_bus_din_6 Z=FE_PHN444_bus_din_6
+ VSS=DVSS VDD=DVDD
XFE_PHC443_bus_din_1 CKBD1 $PINS I=FE_PHN425_bus_din_1 Z=FE_PHN443_bus_din_1
+ VSS=DVSS VDD=DVDD
XFE_PHC442_bus_din_2 CKBD1 $PINS I=FE_PHN423_bus_din_2 Z=FE_PHN442_bus_din_2
+ VSS=DVSS VDD=DVDD
XFE_PHC441_bus_din_3 DEL0 $PINS I=FE_PHN428_bus_din_3 Z=FE_PHN441_bus_din_3
+ VSS=DVSS VDD=DVDD
XFE_PHC440_bus_din_4 DEL0 $PINS I=FE_PHN427_bus_din_4 Z=FE_PHN440_bus_din_4
+ VSS=DVSS VDD=DVDD
XFE_PHC439_bus_din_0 CKBD1 $PINS I=FE_PHN480_bus_din_0 Z=FE_PHN439_bus_din_0
+ VSS=DVSS VDD=DVDD
XFE_PHC438_bus_din_1 DEL005 $PINS I=FE_PHN412_bus_din_1 Z=FE_PHN438_bus_din_1
+ VSS=DVSS VDD=DVDD
XFE_PHC437_bus_din_3 DEL015 $PINS I=FE_PHN174_bus_din_3 Z=FE_PHN437_bus_din_3
+ VSS=DVSS VDD=DVDD
XFE_PHC436_bus_din_2 CKBD0 $PINS I=FE_PHN463_bus_din_2 Z=FE_PHN436_bus_din_2
+ VSS=DVSS VDD=DVDD
XFE_PHC435_bus_din_4 DEL015 $PINS I=FE_PHN435_bus_din_4 Z=FE_PHN422_bus_din_4
+ VSS=DVSS VDD=DVDD
XFE_PHC434_bus_din_6 DEL01 $PINS I=FE_PHN431_bus_din_6 Z=FE_PHN434_bus_din_6
+ VSS=DVSS VDD=DVDD
XFE_PHC433_bus_din_7 DEL0 $PINS I=FE_PHN510_bus_din_7 Z=FE_PHN420_bus_din_7
+ VSS=DVSS VDD=DVDD
XFE_PHC432_bus_din_0 CKBD1 $PINS I=FE_PHN449_bus_din_0 Z=FE_PHN432_bus_din_0
+ VSS=DVSS VDD=DVDD
XFE_PHC431_bus_din_6 DEL01 $PINS I=FE_PHN411_bus_din_6 Z=FE_PHN431_bus_din_6
+ VSS=DVSS VDD=DVDD
XFE_PHC430_bus_din_2 DEL01 $PINS I=FE_PHN436_bus_din_2 Z=FE_PHN430_bus_din_2
+ VSS=DVSS VDD=DVDD
XFE_PHC429_bus_din_1 CKBD1 $PINS I=FE_PHN175_bus_din_1 Z=FE_PHN429_bus_din_1
+ VSS=DVSS VDD=DVDD
XFE_PHC428_bus_din_3 DEL0 $PINS I=FE_PHN456_bus_din_3 Z=FE_PHN428_bus_din_3
+ VSS=DVSS VDD=DVDD
XFE_PHC427_bus_din_4 DEL0 $PINS I=FE_PHN176_bus_din_4 Z=FE_PHN427_bus_din_4
+ VSS=DVSS VDD=DVDD
XFE_PHC426_bus_din_7 DEL0 $PINS I=FE_PHN179_bus_din_7 Z=FE_PHN426_bus_din_7
+ VSS=DVSS VDD=DVDD
XFE_PHC425_bus_din_1 DEL005 $PINS I=FE_PHN448_bus_din_1 Z=FE_PHN425_bus_din_1
+ VSS=DVSS VDD=DVDD
XFE_PHC424_bus_din_0 CKBD1 $PINS I=FE_PHN177_bus_din_0 Z=FE_PHN424_bus_din_0
+ VSS=DVSS VDD=DVDD
XFE_PHC423_bus_din_2 DEL01 $PINS I=FE_PHN173_bus_din_2 Z=FE_PHN423_bus_din_2
+ VSS=DVSS VDD=DVDD
XFE_PHC422_bus_din_4 CKBD1 $PINS I=FE_PHN422_bus_din_4 Z=FE_PHN176_bus_din_4
+ VSS=DVSS VDD=DVDD
XFE_PHC421_bus_din_3 CKBD1 $PINS I=FE_PHN421_bus_din_3 Z=FE_PHN174_bus_din_3
+ VSS=DVSS VDD=DVDD
XFE_PHC420_bus_din_7 DEL0 $PINS I=FE_PHN420_bus_din_7 Z=FE_PHN179_bus_din_7
+ VSS=DVSS VDD=DVDD
XFE_PHC419_bus_addr_7 CKBD1 $PINS I=bus_addr<7> Z=FE_PHN419_bus_addr_7 VSS=DVSS
+ VDD=DVDD
XFE_PHC418_FE_OFN4_sram_addr_7 BUFFD1 $PINS I=FE_OFN4_sram_addr_7
+ Z=FE_PHN418_FE_OFN4_sram_addr_7 VSS=DVSS VDD=DVDD
XFE_PHC417_bus_addr_11 BUFFD1 $PINS I=bus_addr<11> Z=FE_PHN417_bus_addr_11
+ VSS=DVSS VDD=DVDD
XFE_PHC416_bus_addr_9 CKBD1 $PINS I=bus_addr<9> Z=FE_PHN416_bus_addr_9 VSS=DVSS
+ VDD=DVDD
XFE_PHC415_bus_addr_6 CKBD1 $PINS I=bus_addr<6> Z=FE_PHN415_bus_addr_6 VSS=DVSS
+ VDD=DVDD
XFE_PHC414_bus_addr_10 CKBD1 $PINS I=FE_PHN183_bus_addr_10
+ Z=FE_PHN414_bus_addr_10 VSS=DVSS VDD=DVDD
XFE_PHC413_bus_addr_2 CKBD0 $PINS I=bus_addr<2> Z=FE_PHN413_bus_addr_2 VSS=DVSS
+ VDD=DVDD
XFE_PHC412_bus_din_1 DEL0 $PINS I=FE_PHN467_bus_din_1 Z=FE_PHN412_bus_din_1
+ VSS=DVSS VDD=DVDD
XFE_PHC411_bus_din_6 DEL0 $PINS I=FE_PHN477_bus_din_6 Z=FE_PHN411_bus_din_6
+ VSS=DVSS VDD=DVDD
XFE_PHC410_bus_din_2 DEL0 $PINS I=FE_PHN410_bus_din_2 Z=FE_PHN173_bus_din_2
+ VSS=DVSS VDD=DVDD
XFE_PHC409_bus_din_5 BUFFD2 $PINS I=FE_PHN409_bus_din_5 Z=FE_PHN536_bus_din_5
+ VSS=DVSS VDD=DVDD
XFE_PHC408_bus_addr_8 BUFFD1 $PINS I=bus_addr<8> Z=FE_PHN408_bus_addr_8
+ VSS=DVSS VDD=DVDD
XFE_PHC407_bus_addr_8 CKBD0 $PINS I=FE_PHN408_bus_addr_8 Z=FE_PHN407_bus_addr_8
+ VSS=DVSS VDD=DVDD
XFE_PHC406_bus_addr_8 DEL005 $PINS I=FE_PHN407_bus_addr_8
+ Z=FE_PHN406_bus_addr_8 VSS=DVSS VDD=DVDD
XFE_PHC405_bus_addr_8 CKBD0 $PINS I=FE_PHN406_bus_addr_8 Z=FE_PHN405_bus_addr_8
+ VSS=DVSS VDD=DVDD
XFE_PHC404_bus_addr_8 CKBD0 $PINS I=FE_PHN405_bus_addr_8 Z=FE_PHN404_bus_addr_8
+ VSS=DVSS VDD=DVDD
XFE_PHC403_bus_addr_8 DEL005 $PINS I=FE_PHN404_bus_addr_8
+ Z=FE_PHN403_bus_addr_8 VSS=DVSS VDD=DVDD
XFE_PHC402_bus_addr_8 CKBD0 $PINS I=FE_PHN403_bus_addr_8 Z=FE_PHN402_bus_addr_8
+ VSS=DVSS VDD=DVDD
XFE_PHC401_tpu_dout_3 CKBD1 $PINS I=FE_PHN398_tpu_dout_3 Z=FE_PHN401_tpu_dout_3
+ VSS=DVSS VDD=DVDD
XFE_PHC400_tpu_dout_1 BUFFD1 $PINS I=FE_PHN378_tpu_dout_1
+ Z=FE_PHN400_tpu_dout_1 VSS=DVSS VDD=DVDD
XFE_PHC399_bus_addr_8 DEL005 $PINS I=FE_PHN402_bus_addr_8
+ Z=FE_PHN399_bus_addr_8 VSS=DVSS VDD=DVDD
XFE_PHC398_tpu_dout_3 DEL005 $PINS I=FE_PHN67_tpu_dout_3 Z=FE_PHN398_tpu_dout_3
+ VSS=DVSS VDD=DVDD
XFE_PHC397_tpu_dout_1 DEL005 $PINS I=FE_PHN400_tpu_dout_1
+ Z=FE_PHN397_tpu_dout_1 VSS=DVSS VDD=DVDD
XFE_PHC396_bus_addr_9 CKBD0 $PINS I=FE_PHN416_bus_addr_9 Z=FE_PHN396_bus_addr_9
+ VSS=DVSS VDD=DVDD
XFE_PHC395_bus_addr_8 CKBD0 $PINS I=FE_PHN399_bus_addr_8 Z=FE_PHN395_bus_addr_8
+ VSS=DVSS VDD=DVDD
XFE_PHC394_tpu_dout_0 CKBD1 $PINS I=FE_PHN141_tpu_dout_0 Z=FE_PHN394_tpu_dout_0
+ VSS=DVSS VDD=DVDD
XFE_PHC393_tpu_dout_3 CKBD0 $PINS I=FE_PHN401_tpu_dout_3 Z=FE_PHN393_tpu_dout_3
+ VSS=DVSS VDD=DVDD
XFE_PHC392_tpu_dout_1 CKBD0 $PINS I=FE_PHN397_tpu_dout_1 Z=FE_PHN392_tpu_dout_1
+ VSS=DVSS VDD=DVDD
XFE_PHC391_bus_addr_9 DEL015 $PINS I=FE_PHN396_bus_addr_9
+ Z=FE_PHN391_bus_addr_9 VSS=DVSS VDD=DVDD
XFE_PHC390_bus_addr_8 DEL005 $PINS I=FE_PHN395_bus_addr_8
+ Z=FE_PHN390_bus_addr_8 VSS=DVSS VDD=DVDD
XFE_PHC389_tpu_dout_1 DEL005 $PINS I=FE_PHN392_tpu_dout_1
+ Z=FE_PHN389_tpu_dout_1 VSS=DVSS VDD=DVDD
XFE_PHC388_tpu_dout_3 CKBD0 $PINS I=FE_PHN393_tpu_dout_3 Z=FE_PHN388_tpu_dout_3
+ VSS=DVSS VDD=DVDD
XFE_PHC387_bus_addr_9 DEL01 $PINS I=FE_PHN391_bus_addr_9 Z=FE_PHN387_bus_addr_9
+ VSS=DVSS VDD=DVDD
XFE_PHC386_tpu_dout_0 CKBD0 $PINS I=FE_PHN394_tpu_dout_0 Z=FE_PHN386_tpu_dout_0
+ VSS=DVSS VDD=DVDD
XFE_PHC385_bus_addr_8 CKBD0 $PINS I=FE_PHN390_bus_addr_8 Z=FE_PHN385_bus_addr_8
+ VSS=DVSS VDD=DVDD
XFE_PHC384_bus_addr_9 DEL005 $PINS I=FE_PHN387_bus_addr_9
+ Z=FE_PHN384_bus_addr_9 VSS=DVSS VDD=DVDD
XFE_PHC383_tpu_dout_1 CKBD0 $PINS I=FE_PHN389_tpu_dout_1 Z=FE_PHN383_tpu_dout_1
+ VSS=DVSS VDD=DVDD
XFE_PHC382_tpu_dout_3 DEL005 $PINS I=FE_PHN388_tpu_dout_3
+ Z=FE_PHN382_tpu_dout_3 VSS=DVSS VDD=DVDD
XFE_PHC381_tpu_dout_0 DEL005 $PINS I=FE_PHN386_tpu_dout_0
+ Z=FE_PHN381_tpu_dout_0 VSS=DVSS VDD=DVDD
XFE_PHC380_bus_addr_8 DEL005 $PINS I=FE_PHN385_bus_addr_8
+ Z=FE_PHN380_bus_addr_8 VSS=DVSS VDD=DVDD
XFE_PHC379_bus_addr_9 DEL005 $PINS I=FE_PHN384_bus_addr_9
+ Z=FE_PHN379_bus_addr_9 VSS=DVSS VDD=DVDD
XFE_PHC378_tpu_dout_1 BUFFD4 $PINS I=FE_PHN373_tpu_dout_1
+ Z=FE_PHN378_tpu_dout_1 VSS=DVSS VDD=DVDD
XFE_PHC377_tpu_dout_3 CKBD0 $PINS I=FE_PHN382_tpu_dout_3 Z=FE_PHN377_tpu_dout_3
+ VSS=DVSS VDD=DVDD
XFE_PHC376_tpu_dout_0 CKBD0 $PINS I=FE_PHN381_tpu_dout_0 Z=FE_PHN376_tpu_dout_0
+ VSS=DVSS VDD=DVDD
XFE_PHC375_bus_addr_9 CKBD0 $PINS I=FE_PHN379_bus_addr_9 Z=FE_PHN375_bus_addr_9
+ VSS=DVSS VDD=DVDD
XFE_PHC374_bus_addr_8 CKBD0 $PINS I=FE_PHN380_bus_addr_8 Z=FE_PHN374_bus_addr_8
+ VSS=DVSS VDD=DVDD
XFE_PHC373_tpu_dout_1 DEL005 $PINS I=FE_PHN99_tpu_dout_1 Z=FE_PHN373_tpu_dout_1
+ VSS=DVSS VDD=DVDD
XFE_PHC372_tpu_dout_3 DEL005 $PINS I=FE_PHN365_tpu_dout_3
+ Z=FE_PHN372_tpu_dout_3 VSS=DVSS VDD=DVDD
XFE_PHC371_tpu_dout_0 DEL005 $PINS I=FE_PHN376_tpu_dout_0
+ Z=FE_PHN371_tpu_dout_0 VSS=DVSS VDD=DVDD
XFE_PHC370_bus_addr_3 CKBD1 $PINS I=bus_addr<3> Z=FE_PHN370_bus_addr_3 VSS=DVSS
+ VDD=DVDD
XFE_PHC369_bus_addr_11 BUFFD1 $PINS I=FE_PHN417_bus_addr_11
+ Z=FE_PHN369_bus_addr_11 VSS=DVSS VDD=DVDD
XFE_PHC368_bus_addr_8 DEL005 $PINS I=FE_PHN374_bus_addr_8
+ Z=FE_PHN368_bus_addr_8 VSS=DVSS VDD=DVDD
XFE_PHC367_bus_addr_9 DEL005 $PINS I=FE_PHN375_bus_addr_9
+ Z=FE_PHN367_bus_addr_9 VSS=DVSS VDD=DVDD
XFE_PHC366_tpu_dout_1 CKBD0 $PINS I=FE_PHN383_tpu_dout_1 Z=FE_PHN366_tpu_dout_1
+ VSS=DVSS VDD=DVDD
XFE_PHC365_tpu_dout_3 DEL005 $PINS I=FE_PHN359_tpu_dout_3
+ Z=FE_PHN365_tpu_dout_3 VSS=DVSS VDD=DVDD
XFE_PHC364_tpu_dout_0 CKBD0 $PINS I=FE_PHN371_tpu_dout_0 Z=FE_PHN364_tpu_dout_0
+ VSS=DVSS VDD=DVDD
XFE_PHC363_bus_addr_3 CKBD0 $PINS I=FE_PHN370_bus_addr_3 Z=FE_PHN363_bus_addr_3
+ VSS=DVSS VDD=DVDD
XFE_PHC362_bus_addr_11 DEL015 $PINS I=FE_PHN369_bus_addr_11
+ Z=FE_PHN362_bus_addr_11 VSS=DVSS VDD=DVDD
XFE_PHC361_bus_addr_9 CKBD0 $PINS I=FE_PHN367_bus_addr_9 Z=FE_PHN361_bus_addr_9
+ VSS=DVSS VDD=DVDD
XFE_PHC360_bus_addr_8 CKBD0 $PINS I=FE_PHN368_bus_addr_8 Z=FE_PHN360_bus_addr_8
+ VSS=DVSS VDD=DVDD
XFE_PHC359_tpu_dout_3 DEL005 $PINS I=FE_PHN377_tpu_dout_3
+ Z=FE_PHN359_tpu_dout_3 VSS=DVSS VDD=DVDD
XFE_PHC358_tpu_dout_1 DEL005 $PINS I=FE_PHN366_tpu_dout_1
+ Z=FE_PHN358_tpu_dout_1 VSS=DVSS VDD=DVDD
XFE_PHC357_tpu_dout_0 CKBD0 $PINS I=FE_PHN364_tpu_dout_0 Z=FE_PHN357_tpu_dout_0
+ VSS=DVSS VDD=DVDD
XFE_PHC356_bus_addr_3 CKBD0 $PINS I=FE_PHN363_bus_addr_3 Z=FE_PHN356_bus_addr_3
+ VSS=DVSS VDD=DVDD
XFE_PHC355_bus_addr_11 DEL015 $PINS I=FE_PHN362_bus_addr_11
+ Z=FE_PHN355_bus_addr_11 VSS=DVSS VDD=DVDD
XFE_PHC354_bus_addr_9 DEL005 $PINS I=FE_PHN361_bus_addr_9
+ Z=FE_PHN354_bus_addr_9 VSS=DVSS VDD=DVDD
XFE_PHC353_bus_addr_8 DEL005 $PINS I=FE_PHN360_bus_addr_8
+ Z=FE_PHN353_bus_addr_8 VSS=DVSS VDD=DVDD
XFE_PHC352_tpu_dout_3 CKBD0 $PINS I=FE_PHN372_tpu_dout_3 Z=FE_PHN352_tpu_dout_3
+ VSS=DVSS VDD=DVDD
XFE_PHC351_tpu_dout_1 CKBD0 $PINS I=FE_PHN358_tpu_dout_1 Z=FE_PHN351_tpu_dout_1
+ VSS=DVSS VDD=DVDD
XFE_PHC350_bus_addr_11 DEL015 $PINS I=FE_PHN355_bus_addr_11
+ Z=FE_PHN350_bus_addr_11 VSS=DVSS VDD=DVDD
XFE_PHC349_bus_addr_7 DEL01 $PINS I=FE_PHN419_bus_addr_7 Z=FE_PHN349_bus_addr_7
+ VSS=DVSS VDD=DVDD
XFE_PHC348_bus_wbuf_0 DEL0 $PINS I=FE_PHN304_bus_wbuf_0 Z=FE_PHN348_bus_wbuf_0
+ VSS=DVSS VDD=DVDD
XFE_PHC347_FE_OFN10_sram_addr_1 DEL0 $PINS I=FE_PHN336_FE_OFN10_sram_addr_1
+ Z=FE_PHN347_FE_OFN10_sram_addr_1 VSS=DVSS VDD=DVDD
XFE_PHC346_bus_addr_11 DEL01 $PINS I=FE_PHN350_bus_addr_11
+ Z=FE_PHN346_bus_addr_11 VSS=DVSS VDD=DVDD
XFE_PHC345_tpu_dout_0 DEL01 $PINS I=FE_PHN357_tpu_dout_0 Z=FE_PHN345_tpu_dout_0
+ VSS=DVSS VDD=DVDD
XFE_PHC344_bus_addr_7 DEL01 $PINS I=FE_PHN349_bus_addr_7 Z=FE_PHN344_bus_addr_7
+ VSS=DVSS VDD=DVDD
XFE_PHC343_bus_wbuf_0 DEL01 $PINS I=FE_PHN324_bus_wbuf_0 Z=FE_PHN343_bus_wbuf_0
+ VSS=DVSS VDD=DVDD
XFE_PHC342_bus_addr_3 DEL01 $PINS I=FE_PHN356_bus_addr_3 Z=FE_PHN342_bus_addr_3
+ VSS=DVSS VDD=DVDD
XFE_PHC341_bus_addr_6 DEL005 $PINS I=FE_PHN322_bus_addr_6
+ Z=FE_PHN341_bus_addr_6 VSS=DVSS VDD=DVDD
XFE_PHC340_bus_addr_5 DEL01 $PINS I=bus_addr<5> Z=FE_PHN340_bus_addr_5 VSS=DVSS
+ VDD=DVDD
XFE_PHC339_bus_addr_4 DEL01 $PINS I=bus_addr<4> Z=FE_PHN339_bus_addr_4 VSS=DVSS
+ VDD=DVDD
XFE_PHC338_tpu_addr_7 CKBD0 $PINS I=tpu_addr<7> Z=FE_PHN338_tpu_addr_7 VSS=DVSS
+ VDD=DVDD
XFE_PHC337_bus_addr_10 CKBD0 $PINS I=bus_addr<10> Z=FE_PHN337_bus_addr_10
+ VSS=DVSS VDD=DVDD
XFE_PHC336_FE_OFN10_sram_addr_1 DEL0 $PINS I=FE_PHN309_FE_OFN10_sram_addr_1
+ Z=FE_PHN336_FE_OFN10_sram_addr_1 VSS=DVSS VDD=DVDD
XFE_PHC335_tpu_dout_31 DEL0 $PINS I=FE_PHN332_tpu_dout_31
+ Z=FE_PHN335_tpu_dout_31 VSS=DVSS VDD=DVDD
XFE_PHC334_FE_OFN11_sram_addr_0 DEL1 $PINS I=FE_PHN308_FE_OFN11_sram_addr_0
+ Z=FE_PHN334_FE_OFN11_sram_addr_0 VSS=DVSS VDD=DVDD
XFE_PHC333_tpu_dout_31 CKBD12 $PINS I=FE_PHN335_tpu_dout_31 Z=tpu_dout<31>
+ VSS=DVSS VDD=DVDD
XFE_PHC331_tpu_dout_12 CKBD1 $PINS I=FE_PHN149_tpu_dout_12
+ Z=FE_PHN331_tpu_dout_12 VSS=DVSS VDD=DVDD
XFE_PHC330_tpu_dout_18 BUFFD1 $PINS I=FE_PHN167_tpu_dout_18
+ Z=FE_PHN330_tpu_dout_18 VSS=DVSS VDD=DVDD
XFE_PHC329_tpu_dout_19 BUFFD1 $PINS I=FE_PHN145_tpu_dout_19
+ Z=FE_PHN329_tpu_dout_19 VSS=DVSS VDD=DVDD
XFE_PHC328_tpu_dout_2 CKBD1 $PINS I=FE_PHN97_tpu_dout_2 Z=FE_PHN328_tpu_dout_2
+ VSS=DVSS VDD=DVDD
XFE_PHC327_tpu_dout_17 CKBD1 $PINS I=FE_PHN147_tpu_dout_17
+ Z=FE_PHN327_tpu_dout_17 VSS=DVSS VDD=DVDD
XFE_PHC326_tpu_dout_5 CKBD1 $PINS I=FE_PHN115_tpu_dout_5 Z=FE_PHN326_tpu_dout_5
+ VSS=DVSS VDD=DVDD
XFE_PHC325_tpu_dout_8 CKBD1 $PINS I=FE_PHN129_tpu_dout_8 Z=FE_PHN325_tpu_dout_8
+ VSS=DVSS VDD=DVDD
XFE_PHC324_bus_wbuf_0 DEL015 $PINS I=FE_PHN348_bus_wbuf_0
+ Z=FE_PHN324_bus_wbuf_0 VSS=DVSS VDD=DVDD
XFE_PHC323_tpu_re DEL01 $PINS I=FE_PHN15_tpu_re Z=FE_PHN323_tpu_re VSS=DVSS
+ VDD=DVDD
XFE_PHC322_bus_addr_6 DEL015 $PINS I=FE_PHN415_bus_addr_6
+ Z=FE_PHN322_bus_addr_6 VSS=DVSS VDD=DVDD
XFE_PHC321_tpu_addr_7 DEL015 $PINS I=FE_PHN338_tpu_addr_7
+ Z=FE_PHN321_tpu_addr_7 VSS=DVSS VDD=DVDD
XFE_PHC320_bus_addr_5 DEL015 $PINS I=FE_PHN340_bus_addr_5
+ Z=FE_PHN320_bus_addr_5 VSS=DVSS VDD=DVDD
XFE_PHC319_bus_addr_4 DEL015 $PINS I=FE_PHN339_bus_addr_4
+ Z=FE_PHN319_bus_addr_4 VSS=DVSS VDD=DVDD
XFE_PHC318_bus_addr_10 DEL015 $PINS I=FE_PHN337_bus_addr_10
+ Z=FE_PHN318_bus_addr_10 VSS=DVSS VDD=DVDD
XFE_PHC317_tpu_dout_23 DEL0 $PINS I=FE_PHN139_tpu_dout_23
+ Z=FE_PHN317_tpu_dout_23 VSS=DVSS VDD=DVDD
XFE_PHC316_tpu_dout_21 DEL0 $PINS I=FE_PHN125_tpu_dout_21
+ Z=FE_PHN316_tpu_dout_21 VSS=DVSS VDD=DVDD
XFE_PHC315_tpu_dout_20 DEL0 $PINS I=FE_PHN123_tpu_dout_20
+ Z=FE_PHN315_tpu_dout_20 VSS=DVSS VDD=DVDD
XFE_PHC314_FE_OFN9_sram_addr_2 DEL0 $PINS I=FE_PHN234_FE_OFN9_sram_addr_2
+ Z=FE_PHN314_FE_OFN9_sram_addr_2 VSS=DVSS VDD=DVDD
XFE_PHC313_FE_OFN8_sram_addr_3 DEL0 $PINS I=FE_PHN233_FE_OFN8_sram_addr_3
+ Z=FE_PHN313_FE_OFN8_sram_addr_3 VSS=DVSS VDD=DVDD
XFE_PHC312_FE_OFN7_sram_addr_4 DEL0 $PINS I=FE_PHN187_FE_OFN7_sram_addr_4
+ Z=FE_PHN312_FE_OFN7_sram_addr_4 VSS=DVSS VDD=DVDD
XFE_PHC311_FE_OFN6_sram_addr_5 DEL0 $PINS I=FE_PHN231_FE_OFN6_sram_addr_5
+ Z=FE_PHN311_FE_OFN6_sram_addr_5 VSS=DVSS VDD=DVDD
XFE_PHC310_FE_OFN5_sram_addr_6 DEL0 $PINS I=FE_PHN232_FE_OFN5_sram_addr_6
+ Z=FE_PHN310_FE_OFN5_sram_addr_6 VSS=DVSS VDD=DVDD
XFE_PHC309_FE_OFN10_sram_addr_1 DEL0 $PINS I=FE_OFN10_sram_addr_1
+ Z=FE_PHN309_FE_OFN10_sram_addr_1 VSS=DVSS VDD=DVDD
XFE_PHC308_FE_OFN11_sram_addr_0 DEL0 $PINS I=FE_OFN11_sram_addr_0
+ Z=FE_PHN308_FE_OFN11_sram_addr_0 VSS=DVSS VDD=DVDD
XFE_PHC307_n_8 BUFFD1 $PINS I=n_8 Z=FE_PHN307_n_8 VSS=DVSS VDD=DVDD
XFE_PHC306_bus_din_1 BUFFD1 $PINS I=bus_din<1> Z=FE_PHN306_bus_din_1 VSS=DVSS
+ VDD=DVDD
XFE_PHC305_bus_din_0 BUFFD1 $PINS I=bus_din<0> Z=FE_PHN305_bus_din_0 VSS=DVSS
+ VDD=DVDD
XFE_PHC304_bus_wbuf_0 DEL0 $PINS I=bus_wbuf<0> Z=FE_PHN304_bus_wbuf_0 VSS=DVSS
+ VDD=DVDD
XFE_PHC303_bus_din_6 CKBD1 $PINS I=bus_din<6> Z=FE_PHN303_bus_din_6 VSS=DVSS
+ VDD=DVDD
XFE_PHC302_bus_din_2 BUFFD1 $PINS I=FE_PHN430_bus_din_2 Z=FE_PHN302_bus_din_2
+ VSS=DVSS VDD=DVDD
XFE_PHC301_bus_din_3 CKBD1 $PINS I=bus_din<3> Z=FE_PHN301_bus_din_3 VSS=DVSS
+ VDD=DVDD
XFE_PHC300_bus_din_4 CKBD1 $PINS I=bus_din<4> Z=FE_PHN300_bus_din_4 VSS=DVSS
+ VDD=DVDD
XFE_PHC299_bus_din_5 CKBD1 $PINS I=bus_din<5> Z=FE_PHN299_bus_din_5 VSS=DVSS
+ VDD=DVDD
XFE_PHC298_bus_din_7 CKBD1 $PINS I=bus_din<7> Z=FE_PHN298_bus_din_7 VSS=DVSS
+ VDD=DVDD
XFE_PHC297_tpu_addr_8 DEL0 $PINS I=tpu_addr<8> Z=FE_PHN297_tpu_addr_8 VSS=DVSS
+ VDD=DVDD
XFE_PHC296_tpu_dout_19 DEL0 $PINS I=FE_PHN329_tpu_dout_19
+ Z=FE_PHN296_tpu_dout_19 VSS=DVSS VDD=DVDD
XFE_PHC295_tpu_dout_18 DEL0 $PINS I=FE_PHN330_tpu_dout_18
+ Z=FE_PHN295_tpu_dout_18 VSS=DVSS VDD=DVDD
XFE_PHC294_tpu_dout_13 DEL0 $PINS I=FE_PHN113_tpu_dout_13
+ Z=FE_PHN294_tpu_dout_13 VSS=DVSS VDD=DVDD
XFE_PHC293_tpu_dout_7 DEL0 $PINS I=FE_PHN131_tpu_dout_7 Z=FE_PHN293_tpu_dout_7
+ VSS=DVSS VDD=DVDD
XFE_PHC292_tpu_dout_11 DEL0 $PINS I=FE_PHN169_tpu_dout_11
+ Z=FE_PHN292_tpu_dout_11 VSS=DVSS VDD=DVDD
XFE_PHC291_tpu_dout_6 DEL0 $PINS I=FE_PHN155_tpu_dout_6 Z=FE_PHN291_tpu_dout_6
+ VSS=DVSS VDD=DVDD
XFE_PHC290_tpu_dout_4 DEL0 $PINS I=FE_PHN61_tpu_dout_4 Z=FE_PHN290_tpu_dout_4
+ VSS=DVSS VDD=DVDD
XFE_PHC289_tpu_dout_9 DEL0 $PINS I=FE_PHN143_tpu_dout_9 Z=FE_PHN289_tpu_dout_9
+ VSS=DVSS VDD=DVDD
XFE_PHC288_tpu_dout_2 DEL0 $PINS I=FE_PHN328_tpu_dout_2 Z=FE_PHN288_tpu_dout_2
+ VSS=DVSS VDD=DVDD
XFE_PHC287_tpu_dout_10 DEL0 $PINS I=FE_PHN83_tpu_dout_10
+ Z=FE_PHN287_tpu_dout_10 VSS=DVSS VDD=DVDD
XFE_PHC286_tpu_dout_8 DEL0 $PINS I=FE_PHN325_tpu_dout_8 Z=FE_PHN286_tpu_dout_8
+ VSS=DVSS VDD=DVDD
XFE_PHC285_tpu_dout_14 DEL0 $PINS I=FE_PHN95_tpu_dout_14
+ Z=FE_PHN285_tpu_dout_14 VSS=DVSS VDD=DVDD
XFE_PHC284_tpu_dout_5 DEL0 $PINS I=FE_PHN326_tpu_dout_5 Z=FE_PHN284_tpu_dout_5
+ VSS=DVSS VDD=DVDD
XFE_PHC283_tpu_dout_17 DEL0 $PINS I=FE_PHN327_tpu_dout_17
+ Z=FE_PHN283_tpu_dout_17 VSS=DVSS VDD=DVDD
XFE_PHC282_tpu_dout_52 DEL1 $PINS I=FE_PHN91_tpu_dout_52
+ Z=FE_PHN282_tpu_dout_52 VSS=DVSS VDD=DVDD
XFE_PHC281_tpu_dout_60 DEL1 $PINS I=FE_PHN93_tpu_dout_60
+ Z=FE_PHN281_tpu_dout_60 VSS=DVSS VDD=DVDD
XFE_PHC280_tpu_dout_56 DEL1 $PINS I=FE_PHN111_tpu_dout_56
+ Z=FE_PHN280_tpu_dout_56 VSS=DVSS VDD=DVDD
XFE_PHC279_tpu_dout_55 DEL1 $PINS I=FE_PHN77_tpu_dout_55
+ Z=FE_PHN279_tpu_dout_55 VSS=DVSS VDD=DVDD
XFE_PHC278_tpu_dout_12 DEL0 $PINS I=FE_PHN331_tpu_dout_12
+ Z=FE_PHN278_tpu_dout_12 VSS=DVSS VDD=DVDD
XFE_PHC277_tpu_dout_54 DEL1 $PINS I=FE_PHN59_tpu_dout_54
+ Z=FE_PHN277_tpu_dout_54 VSS=DVSS VDD=DVDD
XFE_PHC276_tpu_dout_58 DEL1 $PINS I=FE_PHN79_tpu_dout_58
+ Z=FE_PHN276_tpu_dout_58 VSS=DVSS VDD=DVDD
XFE_PHC275_tpu_dout_57 DEL1 $PINS I=FE_PHN55_tpu_dout_57
+ Z=FE_PHN275_tpu_dout_57 VSS=DVSS VDD=DVDD
XFE_PHC274_tpu_dout_59 DEL1 $PINS I=FE_PHN109_tpu_dout_59
+ Z=FE_PHN274_tpu_dout_59 VSS=DVSS VDD=DVDD
XFE_PHC273_tpu_dout_50 DEL1 $PINS I=FE_PHN49_tpu_dout_50
+ Z=FE_PHN273_tpu_dout_50 VSS=DVSS VDD=DVDD
XFE_PHC272_tpu_dout_51 DEL1 $PINS I=FE_PHN51_tpu_dout_51
+ Z=FE_PHN272_tpu_dout_51 VSS=DVSS VDD=DVDD
XFE_PHC271_tpu_dout_53 DEL1 $PINS I=FE_PHN53_tpu_dout_53
+ Z=FE_PHN271_tpu_dout_53 VSS=DVSS VDD=DVDD
XFE_PHC270_tpu_dout_62 DEL1 $PINS I=FE_PHN81_tpu_dout_62
+ Z=FE_PHN270_tpu_dout_62 VSS=DVSS VDD=DVDD
XFE_PHC269_tpu_dout_47 DEL1 $PINS I=FE_PHN107_tpu_dout_47
+ Z=FE_PHN269_tpu_dout_47 VSS=DVSS VDD=DVDD
XFE_PHC268_tpu_dout_48 DEL1 $PINS I=FE_PHN47_tpu_dout_48
+ Z=FE_PHN268_tpu_dout_48 VSS=DVSS VDD=DVDD
XFE_PHC267_tpu_dout_49 DEL1 $PINS I=FE_PHN63_tpu_dout_49
+ Z=FE_PHN267_tpu_dout_49 VSS=DVSS VDD=DVDD
XFE_PHC266_tpu_dout_61 DEL1 $PINS I=FE_PHN57_tpu_dout_61
+ Z=FE_PHN266_tpu_dout_61 VSS=DVSS VDD=DVDD
XFE_PHC265_tpu_dout_44 DEL1 $PINS I=FE_PHN75_tpu_dout_44
+ Z=FE_PHN265_tpu_dout_44 VSS=DVSS VDD=DVDD
XFE_PHC264_tpu_dout_63 DEL1 $PINS I=FE_PHN65_tpu_dout_63
+ Z=FE_PHN264_tpu_dout_63 VSS=DVSS VDD=DVDD
XFE_PHC263_tpu_dout_40 DEL1 $PINS I=FE_PHN105_tpu_dout_40
+ Z=FE_PHN263_tpu_dout_40 VSS=DVSS VDD=DVDD
XFE_PHC262_tpu_dout_46 DEL1 $PINS I=FE_PHN73_tpu_dout_46
+ Z=FE_PHN262_tpu_dout_46 VSS=DVSS VDD=DVDD
XFE_PHC261_tpu_dout_43 DEL1 $PINS I=FE_PHN45_tpu_dout_43
+ Z=FE_PHN261_tpu_dout_43 VSS=DVSS VDD=DVDD
XFE_PHC260_tpu_dout_39 DEL1 $PINS I=FE_PHN71_tpu_dout_39
+ Z=FE_PHN260_tpu_dout_39 VSS=DVSS VDD=DVDD
XFE_PHC259_tpu_dout_45 DEL1 $PINS I=FE_PHN119_tpu_dout_45
+ Z=FE_PHN259_tpu_dout_45 VSS=DVSS VDD=DVDD
XFE_PHC258_tpu_dout_41 DEL1 $PINS I=FE_PHN69_tpu_dout_41
+ Z=FE_PHN258_tpu_dout_41 VSS=DVSS VDD=DVDD
XFE_PHC257_tpu_dout_38 DEL1 $PINS I=FE_PHN103_tpu_dout_38
+ Z=FE_PHN257_tpu_dout_38 VSS=DVSS VDD=DVDD
XFE_PHC256_tpu_dout_37 DEL1 $PINS I=FE_PHN89_tpu_dout_37
+ Z=FE_PHN256_tpu_dout_37 VSS=DVSS VDD=DVDD
XFE_PHC255_tpu_dout_36 DEL1 $PINS I=FE_PHN117_tpu_dout_36
+ Z=FE_PHN255_tpu_dout_36 VSS=DVSS VDD=DVDD
XFE_PHC254_tpu_dout_32 DEL1 $PINS I=FE_PHN87_tpu_dout_32
+ Z=FE_PHN254_tpu_dout_32 VSS=DVSS VDD=DVDD
XFE_PHC253_tpu_dout_34 DEL1 $PINS I=FE_PHN101_tpu_dout_34
+ Z=FE_PHN253_tpu_dout_34 VSS=DVSS VDD=DVDD
XFE_PHC252_tpu_dout_35 DEL1 $PINS I=FE_PHN85_tpu_dout_35
+ Z=FE_PHN252_tpu_dout_35 VSS=DVSS VDD=DVDD
XFE_PHC251_tpu_dout_33 DEL1 $PINS I=FE_PHN133_tpu_dout_33
+ Z=FE_PHN251_tpu_dout_33 VSS=DVSS VDD=DVDD
XFE_PHC250_tpu_dout_27 DEL1 $PINS I=FE_PHN171_tpu_dout_27
+ Z=FE_PHN250_tpu_dout_27 VSS=DVSS VDD=DVDD
XFE_PHC249_tpu_dout_24 DEL1 $PINS I=FE_PHN163_tpu_dout_24
+ Z=FE_PHN249_tpu_dout_24 VSS=DVSS VDD=DVDD
XFE_PHC248_tpu_dout_22 DEL1 $PINS I=FE_PHN165_tpu_dout_22
+ Z=FE_PHN248_tpu_dout_22 VSS=DVSS VDD=DVDD
XFE_PHC247_tpu_dout_25 DEL1 $PINS I=FE_PHN153_tpu_dout_25
+ Z=FE_PHN247_tpu_dout_25 VSS=DVSS VDD=DVDD
XFE_PHC246_tpu_dout_26 DEL1 $PINS I=FE_PHN137_tpu_dout_26
+ Z=FE_PHN246_tpu_dout_26 VSS=DVSS VDD=DVDD
XFE_PHC245_tpu_dout_28 DEL1 $PINS I=FE_PHN157_tpu_dout_28
+ Z=FE_PHN245_tpu_dout_28 VSS=DVSS VDD=DVDD
XFE_PHC244_tpu_dout_29 DEL1 $PINS I=FE_PHN135_tpu_dout_29
+ Z=FE_PHN244_tpu_dout_29 VSS=DVSS VDD=DVDD
XFE_PHC243_tpu_dout_30 DEL1 $PINS I=FE_PHN161_tpu_dout_30
+ Z=FE_PHN243_tpu_dout_30 VSS=DVSS VDD=DVDD
XFE_PHC242_bus_addr_11 DEL0 $PINS I=FE_PHN346_bus_addr_11
+ Z=FE_PHN242_bus_addr_11 VSS=DVSS VDD=DVDD
XFE_PHC241_bus_addr_8 DEL0 $PINS I=FE_PHN353_bus_addr_8 Z=FE_PHN241_bus_addr_8
+ VSS=DVSS VDD=DVDD
XFE_PHC240_bus_addr_9 DEL0 $PINS I=FE_PHN354_bus_addr_9 Z=FE_PHN240_bus_addr_9
+ VSS=DVSS VDD=DVDD
XFE_PHC239_tpu_re DEL0 $PINS I=FE_PHN323_tpu_re Z=FE_PHN239_tpu_re VSS=DVSS
+ VDD=DVDD
XFE_PHC238_tpu_dout_42 DEL0 $PINS I=FE_PHN121_tpu_dout_42
+ Z=FE_PHN238_tpu_dout_42 VSS=DVSS VDD=DVDD
XFE_PHC237_tpu_dout_16 DEL0 $PINS I=FE_PHN159_tpu_dout_16
+ Z=FE_PHN237_tpu_dout_16 VSS=DVSS VDD=DVDD
XFE_PHC236_tpu_dout_15 DEL0 $PINS I=FE_PHN127_tpu_dout_15
+ Z=FE_PHN236_tpu_dout_15 VSS=DVSS VDD=DVDD
XFE_PHC235_bus_addr_1 DEL0 $PINS I=FE_PHN12_bus_addr_1 Z=FE_PHN235_bus_addr_1
+ VSS=DVSS VDD=DVDD
XFE_PHC234_FE_OFN9_sram_addr_2 DEL1 $PINS I=FE_OFN9_sram_addr_2
+ Z=FE_PHN234_FE_OFN9_sram_addr_2 VSS=DVSS VDD=DVDD
XFE_PHC233_FE_OFN8_sram_addr_3 DEL1 $PINS I=FE_OFN8_sram_addr_3
+ Z=FE_PHN233_FE_OFN8_sram_addr_3 VSS=DVSS VDD=DVDD
XFE_PHC232_FE_OFN5_sram_addr_6 DEL1 $PINS I=FE_OFN5_sram_addr_6
+ Z=FE_PHN232_FE_OFN5_sram_addr_6 VSS=DVSS VDD=DVDD
XFE_PHC231_FE_OFN6_sram_addr_5 DEL1 $PINS I=FE_OFN6_sram_addr_5
+ Z=FE_PHN231_FE_OFN6_sram_addr_5 VSS=DVSS VDD=DVDD
XFE_PHC230_bus_wbuf_57 DEL2 $PINS I=bus_wbuf<57> Z=FE_PHN230_bus_wbuf_57
+ VSS=DVSS VDD=DVDD
XFE_PHC229_bus_wbuf_58 DEL2 $PINS I=bus_wbuf<58> Z=FE_PHN229_bus_wbuf_58
+ VSS=DVSS VDD=DVDD
XFE_PHC228_bus_wbuf_59 DEL2 $PINS I=bus_wbuf<59> Z=FE_PHN228_bus_wbuf_59
+ VSS=DVSS VDD=DVDD
XFE_PHC227_bus_wbuf_61 DEL2 $PINS I=bus_wbuf<61> Z=FE_PHN227_bus_wbuf_61
+ VSS=DVSS VDD=DVDD
XFE_PHC226_bus_wbuf_60 DEL2 $PINS I=bus_wbuf<60> Z=FE_PHN226_bus_wbuf_60
+ VSS=DVSS VDD=DVDD
XFE_PHC225_bus_wbuf_63 DEL2 $PINS I=bus_wbuf<63> Z=FE_PHN225_bus_wbuf_63
+ VSS=DVSS VDD=DVDD
XFE_PHC224_bus_wbuf_56 DEL2 $PINS I=bus_wbuf<56> Z=FE_PHN224_bus_wbuf_56
+ VSS=DVSS VDD=DVDD
XFE_PHC223_bus_wbuf_62 DEL2 $PINS I=bus_wbuf<62> Z=FE_PHN223_bus_wbuf_62
+ VSS=DVSS VDD=DVDD
XFE_PHC222_bus_wbuf_47 DEL2 $PINS I=bus_wbuf<47> Z=FE_PHN222_bus_wbuf_47
+ VSS=DVSS VDD=DVDD
XFE_PHC221_bus_wbuf_46 DEL2 $PINS I=bus_wbuf<46> Z=FE_PHN221_bus_wbuf_46
+ VSS=DVSS VDD=DVDD
XFE_PHC220_bus_wbuf_43 DEL2 $PINS I=bus_wbuf<43> Z=FE_PHN220_bus_wbuf_43
+ VSS=DVSS VDD=DVDD
XFE_PHC219_bus_wbuf_41 DEL2 $PINS I=bus_wbuf<41> Z=FE_PHN219_bus_wbuf_41
+ VSS=DVSS VDD=DVDD
XFE_PHC218_bus_wbuf_45 DEL2 $PINS I=bus_wbuf<45> Z=FE_PHN218_bus_wbuf_45
+ VSS=DVSS VDD=DVDD
XFE_PHC217_bus_wbuf_32 DEL2 $PINS I=bus_wbuf<32> Z=FE_PHN217_bus_wbuf_32
+ VSS=DVSS VDD=DVDD
XFE_PHC216_bus_wbuf_44 DEL2 $PINS I=bus_wbuf<44> Z=FE_PHN216_bus_wbuf_44
+ VSS=DVSS VDD=DVDD
XFE_PHC215_bus_wbuf_42 DEL2 $PINS I=bus_wbuf<42> Z=FE_PHN215_bus_wbuf_42
+ VSS=DVSS VDD=DVDD
XFE_PHC214_bus_wbuf_38 DEL2 $PINS I=bus_wbuf<38> Z=FE_PHN214_bus_wbuf_38
+ VSS=DVSS VDD=DVDD
XFE_PHC213_bus_wbuf_37 DEL2 $PINS I=bus_wbuf<37> Z=FE_PHN213_bus_wbuf_37
+ VSS=DVSS VDD=DVDD
XFE_PHC212_bus_wbuf_40 DEL2 $PINS I=bus_wbuf<40> Z=FE_PHN212_bus_wbuf_40
+ VSS=DVSS VDD=DVDD
XFE_PHC211_bus_wbuf_39 DEL2 $PINS I=bus_wbuf<39> Z=FE_PHN211_bus_wbuf_39
+ VSS=DVSS VDD=DVDD
XFE_PHC210_bus_wbuf_36 DEL2 $PINS I=bus_wbuf<36> Z=FE_PHN210_bus_wbuf_36
+ VSS=DVSS VDD=DVDD
XFE_PHC209_bus_wbuf_35 DEL2 $PINS I=bus_wbuf<35> Z=FE_PHN209_bus_wbuf_35
+ VSS=DVSS VDD=DVDD
XFE_PHC208_bus_wbuf_34 DEL2 $PINS I=bus_wbuf<34> Z=FE_PHN208_bus_wbuf_34
+ VSS=DVSS VDD=DVDD
XFE_PHC207_bus_wbuf_33 DEL2 $PINS I=bus_wbuf<33> Z=FE_PHN207_bus_wbuf_33
+ VSS=DVSS VDD=DVDD
XFE_PHC206_FE_OFN4_sram_addr_7 DEL1 $PINS I=FE_PHN418_FE_OFN4_sram_addr_7
+ Z=FE_PHN206_FE_OFN4_sram_addr_7 VSS=DVSS VDD=DVDD
XFE_PHC205_bus_wbuf_18 DEL2 $PINS I=bus_wbuf<18> Z=FE_PHN205_bus_wbuf_18
+ VSS=DVSS VDD=DVDD
XFE_PHC204_bus_wbuf_17 DEL2 $PINS I=bus_wbuf<17> Z=FE_PHN204_bus_wbuf_17
+ VSS=DVSS VDD=DVDD
XFE_PHC203_bus_wbuf_27 DEL2 $PINS I=bus_wbuf<27> Z=FE_PHN203_bus_wbuf_27
+ VSS=DVSS VDD=DVDD
XFE_PHC202_bus_wbuf_22 DEL2 $PINS I=bus_wbuf<22> Z=FE_PHN202_bus_wbuf_22
+ VSS=DVSS VDD=DVDD
XFE_PHC201_bus_wbuf_21 DEL2 $PINS I=bus_wbuf<21> Z=FE_PHN201_bus_wbuf_21
+ VSS=DVSS VDD=DVDD
XFE_PHC200_bus_wbuf_20 DEL2 $PINS I=bus_wbuf<20> Z=FE_PHN200_bus_wbuf_20
+ VSS=DVSS VDD=DVDD
XFE_PHC199_bus_wbuf_16 DEL2 $PINS I=bus_wbuf<16> Z=FE_PHN199_bus_wbuf_16
+ VSS=DVSS VDD=DVDD
XFE_PHC198_bus_wbuf_26 DEL2 $PINS I=bus_wbuf<26> Z=FE_PHN198_bus_wbuf_26
+ VSS=DVSS VDD=DVDD
XFE_PHC197_bus_wbuf_25 DEL2 $PINS I=bus_wbuf<25> Z=FE_PHN197_bus_wbuf_25
+ VSS=DVSS VDD=DVDD
XFE_PHC196_bus_wbuf_23 DEL2 $PINS I=bus_wbuf<23> Z=FE_PHN196_bus_wbuf_23
+ VSS=DVSS VDD=DVDD
XFE_PHC195_bus_wbuf_29 DEL2 $PINS I=bus_wbuf<29> Z=FE_PHN195_bus_wbuf_29
+ VSS=DVSS VDD=DVDD
XFE_PHC194_bus_wbuf_28 DEL2 $PINS I=bus_wbuf<28> Z=FE_PHN194_bus_wbuf_28
+ VSS=DVSS VDD=DVDD
XFE_PHC193_bus_wbuf_19 DEL2 $PINS I=bus_wbuf<19> Z=FE_PHN193_bus_wbuf_19
+ VSS=DVSS VDD=DVDD
XFE_PHC192_bus_wbuf_31 DEL2 $PINS I=bus_wbuf<31> Z=FE_PHN192_bus_wbuf_31
+ VSS=DVSS VDD=DVDD
XFE_PHC191_bus_wbuf_30 DEL2 $PINS I=bus_wbuf<30> Z=FE_PHN191_bus_wbuf_30
+ VSS=DVSS VDD=DVDD
XFE_PHC190_bus_wbuf_24 DEL2 $PINS I=bus_wbuf<24> Z=FE_PHN190_bus_wbuf_24
+ VSS=DVSS VDD=DVDD
XFE_PHC189_n_91 DEL2 $PINS I=n_91 Z=FE_PHN189_n_91 VSS=DVSS VDD=DVDD
XFE_PHC188_n_4 DEL2 $PINS I=n_4 Z=FE_PHN188_n_4 VSS=DVSS VDD=DVDD
XFE_PHC187_FE_OFN7_sram_addr_4 DEL1 $PINS I=FE_OFN7_sram_addr_4
+ Z=FE_PHN187_FE_OFN7_sram_addr_4 VSS=DVSS VDD=DVDD
XFE_PHC186_n_10 DEL1 $PINS I=n_10 Z=FE_PHN186_n_10 VSS=DVSS VDD=DVDD
XFE_PHC185_n_12 DEL1 $PINS I=n_12 Z=FE_PHN185_n_12 VSS=DVSS VDD=DVDD
XFE_PHC184_n_6 DEL2 $PINS I=n_6 Z=FE_PHN184_n_6 VSS=DVSS VDD=DVDD
XFE_PHC183_bus_addr_10 DEL1 $PINS I=FE_PHN318_bus_addr_10
+ Z=FE_PHN183_bus_addr_10 VSS=DVSS VDD=DVDD
XFE_PHC182_FE_OFN3_sram_addr_8 DEL1 $PINS I=FE_OFN3_sram_addr_8
+ Z=FE_PHN182_FE_OFN3_sram_addr_8 VSS=DVSS VDD=DVDD
XFE_PHC181_n_3 DEL1 $PINS I=n_3 Z=FE_PHN181_n_3 VSS=DVSS VDD=DVDD
XFE_PHC180_bus_din_6 BUFFD1 $PINS I=FE_PHN303_bus_din_6 Z=FE_PHN489_bus_din_6
+ VSS=DVSS VDD=DVDD
XFE_PHC179_bus_din_7 BUFFD2 $PINS I=FE_PHN298_bus_din_7 Z=FE_PHN433_bus_din_7
+ VSS=DVSS VDD=DVDD
XFE_PHC178_bus_din_5 BUFFD2 $PINS I=FE_PHN299_bus_din_5 Z=FE_PHN535_bus_din_5
+ VSS=DVSS VDD=DVDD
XFE_PHC177_bus_din_0 BUFFD2 $PINS I=FE_PHN305_bus_din_0 Z=FE_PHN177_bus_din_0
+ VSS=DVSS VDD=DVDD
XFE_PHC176_bus_din_4 BUFFD2 $PINS I=FE_PHN300_bus_din_4 Z=FE_PHN476_bus_din_4
+ VSS=DVSS VDD=DVDD
XFE_PHC175_bus_din_1 BUFFD2 $PINS I=FE_PHN306_bus_din_1 Z=FE_PHN175_bus_din_1
+ VSS=DVSS VDD=DVDD
XFE_PHC174_bus_din_3 BUFFD2 $PINS I=FE_PHN301_bus_din_3 Z=FE_PHN501_bus_din_3
+ VSS=DVSS VDD=DVDD
XFE_PHC173_bus_din_2 BUFFD2 $PINS I=FE_PHN302_bus_din_2 Z=FE_PHN410_bus_din_2
+ VSS=DVSS VDD=DVDD
XFE_PHC172_tpu_dout_27 BUFFD8 $PINS I=FE_PHN250_tpu_dout_27 Z=tpu_dout<27>
+ VSS=DVSS VDD=DVDD
XFE_PHC170_tpu_dout_11 CKBD12 $PINS I=FE_PHN292_tpu_dout_11 Z=tpu_dout<11>
+ VSS=DVSS VDD=DVDD
XFE_PHC168_tpu_dout_18 BUFFD8 $PINS I=FE_PHN295_tpu_dout_18 Z=tpu_dout<18>
+ VSS=DVSS VDD=DVDD
XFE_PHC166_tpu_dout_22 BUFFD8 $PINS I=FE_PHN248_tpu_dout_22 Z=tpu_dout<22>
+ VSS=DVSS VDD=DVDD
XFE_PHC164_tpu_dout_24 BUFFD8 $PINS I=FE_PHN249_tpu_dout_24 Z=tpu_dout<24>
+ VSS=DVSS VDD=DVDD
XFE_PHC162_tpu_dout_30 BUFFD8 $PINS I=FE_PHN243_tpu_dout_30 Z=tpu_dout<30>
+ VSS=DVSS VDD=DVDD
XFE_PHC160_tpu_dout_16 BUFFD8 $PINS I=FE_PHN237_tpu_dout_16 Z=tpu_dout<16>
+ VSS=DVSS VDD=DVDD
XFE_PHC158_tpu_dout_28 BUFFD8 $PINS I=FE_PHN245_tpu_dout_28 Z=tpu_dout<28>
+ VSS=DVSS VDD=DVDD
XFE_PHC156_tpu_dout_6 BUFFD8 $PINS I=FE_PHN291_tpu_dout_6 Z=tpu_dout<6>
+ VSS=DVSS VDD=DVDD
XFE_PHC154_tpu_dout_25 BUFFD8 $PINS I=FE_PHN247_tpu_dout_25 Z=tpu_dout<25>
+ VSS=DVSS VDD=DVDD
XFE_PHC152_tpu_dout_31 BUFFD8 $PINS I=FE_PHN151_tpu_dout_31
+ Z=FE_PHN332_tpu_dout_31 VSS=DVSS VDD=DVDD
XFE_PHC150_tpu_dout_12 BUFFD8 $PINS I=FE_PHN278_tpu_dout_12 Z=tpu_dout<12>
+ VSS=DVSS VDD=DVDD
XFE_PHC148_tpu_dout_17 BUFFD8 $PINS I=FE_PHN283_tpu_dout_17 Z=tpu_dout<17>
+ VSS=DVSS VDD=DVDD
XFE_PHC146_tpu_dout_19 BUFFD8 $PINS I=FE_PHN296_tpu_dout_19 Z=tpu_dout<19>
+ VSS=DVSS VDD=DVDD
XFE_PHC144_tpu_dout_9 BUFFD8 $PINS I=FE_PHN289_tpu_dout_9 Z=tpu_dout<9>
+ VSS=DVSS VDD=DVDD
XFE_PHC142_tpu_dout_0 BUFFD8 $PINS I=FE_PHN345_tpu_dout_0 Z=tpu_dout<0>
+ VSS=DVSS VDD=DVDD
XFE_PHC140_tpu_dout_23 BUFFD8 $PINS I=FE_PHN317_tpu_dout_23 Z=tpu_dout<23>
+ VSS=DVSS VDD=DVDD
XFE_PHC138_tpu_dout_26 BUFFD8 $PINS I=FE_PHN246_tpu_dout_26 Z=tpu_dout<26>
+ VSS=DVSS VDD=DVDD
XFE_PHC136_tpu_dout_29 BUFFD8 $PINS I=FE_PHN244_tpu_dout_29 Z=tpu_dout<29>
+ VSS=DVSS VDD=DVDD
XFE_PHC134_tpu_dout_33 BUFFD8 $PINS I=FE_PHN251_tpu_dout_33 Z=tpu_dout<33>
+ VSS=DVSS VDD=DVDD
XFE_PHC132_tpu_dout_7 BUFFD8 $PINS I=FE_PHN293_tpu_dout_7 Z=tpu_dout<7>
+ VSS=DVSS VDD=DVDD
XFE_PHC130_tpu_dout_8 BUFFD8 $PINS I=FE_PHN286_tpu_dout_8 Z=tpu_dout<8>
+ VSS=DVSS VDD=DVDD
XFE_PHC128_tpu_dout_15 BUFFD8 $PINS I=FE_PHN236_tpu_dout_15 Z=tpu_dout<15>
+ VSS=DVSS VDD=DVDD
XFE_PHC126_tpu_dout_21 BUFFD8 $PINS I=FE_PHN316_tpu_dout_21 Z=tpu_dout<21>
+ VSS=DVSS VDD=DVDD
XFE_PHC124_tpu_dout_20 BUFFD8 $PINS I=FE_PHN315_tpu_dout_20 Z=tpu_dout<20>
+ VSS=DVSS VDD=DVDD
XFE_PHC122_tpu_dout_42 BUFFD8 $PINS I=FE_PHN238_tpu_dout_42 Z=tpu_dout<42>
+ VSS=DVSS VDD=DVDD
XFE_PHC120_tpu_dout_45 BUFFD8 $PINS I=FE_PHN259_tpu_dout_45 Z=tpu_dout<45>
+ VSS=DVSS VDD=DVDD
XFE_PHC118_tpu_dout_36 BUFFD8 $PINS I=FE_PHN255_tpu_dout_36 Z=tpu_dout<36>
+ VSS=DVSS VDD=DVDD
XFE_PHC116_tpu_dout_5 BUFFD8 $PINS I=FE_PHN284_tpu_dout_5 Z=tpu_dout<5>
+ VSS=DVSS VDD=DVDD
XFE_PHC114_tpu_dout_13 BUFFD8 $PINS I=FE_PHN294_tpu_dout_13 Z=tpu_dout<13>
+ VSS=DVSS VDD=DVDD
XFE_PHC112_tpu_dout_56 CKBD12 $PINS I=FE_PHN280_tpu_dout_56 Z=tpu_dout<56>
+ VSS=DVSS VDD=DVDD
XFE_PHC110_tpu_dout_59 CKBD12 $PINS I=FE_PHN274_tpu_dout_59 Z=tpu_dout<59>
+ VSS=DVSS VDD=DVDD
XFE_PHC108_tpu_dout_47 BUFFD8 $PINS I=FE_PHN269_tpu_dout_47 Z=tpu_dout<47>
+ VSS=DVSS VDD=DVDD
XFE_PHC106_tpu_dout_40 BUFFD8 $PINS I=FE_PHN263_tpu_dout_40 Z=tpu_dout<40>
+ VSS=DVSS VDD=DVDD
XFE_PHC104_tpu_dout_38 BUFFD8 $PINS I=FE_PHN257_tpu_dout_38 Z=tpu_dout<38>
+ VSS=DVSS VDD=DVDD
XFE_PHC102_tpu_dout_34 BUFFD8 $PINS I=FE_PHN253_tpu_dout_34 Z=tpu_dout<34>
+ VSS=DVSS VDD=DVDD
XFE_PHC100_tpu_dout_1 BUFFD8 $PINS I=FE_PHN351_tpu_dout_1 Z=tpu_dout<1>
+ VSS=DVSS VDD=DVDD
XFE_PHC98_tpu_dout_2 BUFFD8 $PINS I=FE_PHN288_tpu_dout_2 Z=tpu_dout<2> VSS=DVSS
+ VDD=DVDD
XFE_PHC96_tpu_dout_14 BUFFD8 $PINS I=FE_PHN285_tpu_dout_14 Z=tpu_dout<14>
+ VSS=DVSS VDD=DVDD
XFE_PHC94_tpu_dout_60 CKBD12 $PINS I=FE_PHN281_tpu_dout_60 Z=tpu_dout<60>
+ VSS=DVSS VDD=DVDD
XFE_PHC92_tpu_dout_52 CKBD12 $PINS I=FE_PHN282_tpu_dout_52 Z=tpu_dout<52>
+ VSS=DVSS VDD=DVDD
XFE_PHC90_tpu_dout_37 BUFFD8 $PINS I=FE_PHN256_tpu_dout_37 Z=tpu_dout<37>
+ VSS=DVSS VDD=DVDD
XFE_PHC88_tpu_dout_32 BUFFD8 $PINS I=FE_PHN254_tpu_dout_32 Z=tpu_dout<32>
+ VSS=DVSS VDD=DVDD
XFE_PHC86_tpu_dout_35 BUFFD8 $PINS I=FE_PHN252_tpu_dout_35 Z=tpu_dout<35>
+ VSS=DVSS VDD=DVDD
XFE_PHC84_tpu_dout_10 BUFFD8 $PINS I=FE_PHN287_tpu_dout_10 Z=tpu_dout<10>
+ VSS=DVSS VDD=DVDD
XFE_PHC82_tpu_dout_62 CKBD12 $PINS I=FE_PHN270_tpu_dout_62 Z=tpu_dout<62>
+ VSS=DVSS VDD=DVDD
XFE_PHC80_tpu_dout_58 BUFFD8 $PINS I=FE_PHN276_tpu_dout_58
+ Z=FE_PDN541_tpu_dout_58 VSS=DVSS VDD=DVDD
XFE_PHC78_tpu_dout_55 CKBD12 $PINS I=FE_PHN279_tpu_dout_55 Z=tpu_dout<55>
+ VSS=DVSS VDD=DVDD
XFE_PHC76_tpu_dout_44 BUFFD8 $PINS I=FE_PHN265_tpu_dout_44 Z=tpu_dout<44>
+ VSS=DVSS VDD=DVDD
XFE_PHC74_tpu_dout_46 BUFFD8 $PINS I=FE_PHN262_tpu_dout_46 Z=tpu_dout<46>
+ VSS=DVSS VDD=DVDD
XFE_PHC72_tpu_dout_39 BUFFD8 $PINS I=FE_PHN260_tpu_dout_39 Z=tpu_dout<39>
+ VSS=DVSS VDD=DVDD
XFE_PHC70_tpu_dout_41 BUFFD8 $PINS I=FE_PHN258_tpu_dout_41 Z=tpu_dout<41>
+ VSS=DVSS VDD=DVDD
XFE_PHC68_tpu_dout_3 BUFFD8 $PINS I=FE_PHN352_tpu_dout_3 Z=tpu_dout<3> VSS=DVSS
+ VDD=DVDD
XFE_PHC66_tpu_dout_63 BUFFD8 $PINS I=FE_PHN264_tpu_dout_63 Z=tpu_dout<63>
+ VSS=DVSS VDD=DVDD
XFE_PHC64_tpu_dout_49 CKBD12 $PINS I=FE_PHN267_tpu_dout_49 Z=tpu_dout<49>
+ VSS=DVSS VDD=DVDD
XFE_PHC62_tpu_dout_4 BUFFD8 $PINS I=FE_PHN290_tpu_dout_4 Z=tpu_dout<4> VSS=DVSS
+ VDD=DVDD
XFE_PHC60_tpu_dout_54 BUFFD8 $PINS I=FE_PHN277_tpu_dout_54
+ Z=FE_PDN539_tpu_dout_54 VSS=DVSS VDD=DVDD
XFE_PHC58_tpu_dout_61 CKBD12 $PINS I=FE_PHN266_tpu_dout_61 Z=tpu_dout<61>
+ VSS=DVSS VDD=DVDD
XFE_PHC56_tpu_dout_57 BUFFD8 $PINS I=FE_PHN275_tpu_dout_57 Z=tpu_dout<57>
+ VSS=DVSS VDD=DVDD
XFE_PHC54_tpu_dout_53 BUFFD8 $PINS I=FE_PHN271_tpu_dout_53 Z=tpu_dout<53>
+ VSS=DVSS VDD=DVDD
XFE_PHC52_tpu_dout_51 BUFFD8 $PINS I=FE_PHN272_tpu_dout_51 Z=tpu_dout<51>
+ VSS=DVSS VDD=DVDD
XFE_PHC50_tpu_dout_50 BUFFD8 $PINS I=FE_PHN273_tpu_dout_50 Z=tpu_dout<50>
+ VSS=DVSS VDD=DVDD
XFE_PHC48_tpu_dout_48 BUFFD8 $PINS I=FE_PHN268_tpu_dout_48 Z=tpu_dout<48>
+ VSS=DVSS VDD=DVDD
XFE_PHC46_tpu_dout_43 BUFFD8 $PINS I=FE_PHN261_tpu_dout_43 Z=tpu_dout<43>
+ VSS=DVSS VDD=DVDD
XFE_PHC44_bus_wbuf_1 DEL2 $PINS I=bus_wbuf<1> Z=FE_PHN44_bus_wbuf_1 VSS=DVSS
+ VDD=DVDD
XFE_PHC43_bus_wbuf_2 DEL2 $PINS I=bus_wbuf<2> Z=FE_PHN43_bus_wbuf_2 VSS=DVSS
+ VDD=DVDD
XFE_PHC42_bus_wbuf_4 DEL2 $PINS I=bus_wbuf<4> Z=FE_PHN42_bus_wbuf_4 VSS=DVSS
+ VDD=DVDD
XFE_PHC41_bus_wbuf_3 DEL2 $PINS I=bus_wbuf<3> Z=FE_PHN41_bus_wbuf_3 VSS=DVSS
+ VDD=DVDD
XFE_PHC40_bus_wbuf_6 DEL2 $PINS I=bus_wbuf<6> Z=FE_PHN40_bus_wbuf_6 VSS=DVSS
+ VDD=DVDD
XFE_PHC39_bus_wbuf_7 DEL2 $PINS I=bus_wbuf<7> Z=FE_PHN39_bus_wbuf_7 VSS=DVSS
+ VDD=DVDD
XFE_PHC38_bus_wbuf_8 DEL2 $PINS I=bus_wbuf<8> Z=FE_PHN38_bus_wbuf_8 VSS=DVSS
+ VDD=DVDD
XFE_PHC37_bus_wbuf_5 DEL2 $PINS I=bus_wbuf<5> Z=FE_PHN37_bus_wbuf_5 VSS=DVSS
+ VDD=DVDD
XFE_PHC36_bus_wbuf_11 DEL2 $PINS I=bus_wbuf<11> Z=FE_PHN36_bus_wbuf_11 VSS=DVSS
+ VDD=DVDD
XFE_PHC35_bus_wbuf_9 DEL2 $PINS I=bus_wbuf<9> Z=FE_PHN35_bus_wbuf_9 VSS=DVSS
+ VDD=DVDD
XFE_PHC34_bus_wbuf_15 DEL2 $PINS I=bus_wbuf<15> Z=FE_PHN34_bus_wbuf_15 VSS=DVSS
+ VDD=DVDD
XFE_PHC33_bus_wbuf_13 DEL2 $PINS I=bus_wbuf<13> Z=FE_PHN33_bus_wbuf_13 VSS=DVSS
+ VDD=DVDD
XFE_PHC32_bus_wbuf_10 DEL2 $PINS I=bus_wbuf<10> Z=FE_PHN32_bus_wbuf_10 VSS=DVSS
+ VDD=DVDD
XFE_PHC31_bus_wbuf_12 DEL2 $PINS I=bus_wbuf<12> Z=FE_PHN31_bus_wbuf_12 VSS=DVSS
+ VDD=DVDD
XFE_PHC30_bus_wbuf_14 DEL2 $PINS I=bus_wbuf<14> Z=FE_PHN30_bus_wbuf_14 VSS=DVSS
+ VDD=DVDD
XFE_PHC29_bus_wbuf_54 DEL2 $PINS I=bus_wbuf<54> Z=FE_PHN29_bus_wbuf_54 VSS=DVSS
+ VDD=DVDD
XFE_PHC28_bus_wbuf_53 DEL2 $PINS I=bus_wbuf<53> Z=FE_PHN28_bus_wbuf_53 VSS=DVSS
+ VDD=DVDD
XFE_PHC27_bus_wbuf_50 DEL2 $PINS I=bus_wbuf<50> Z=FE_PHN27_bus_wbuf_50 VSS=DVSS
+ VDD=DVDD
XFE_PHC26_bus_wbuf_55 DEL2 $PINS I=bus_wbuf<55> Z=FE_PHN26_bus_wbuf_55 VSS=DVSS
+ VDD=DVDD
XFE_PHC25_bus_wbuf_51 DEL2 $PINS I=bus_wbuf<51> Z=FE_PHN25_bus_wbuf_51 VSS=DVSS
+ VDD=DVDD
XFE_PHC24_bus_wbuf_52 DEL2 $PINS I=bus_wbuf<52> Z=FE_PHN24_bus_wbuf_52 VSS=DVSS
+ VDD=DVDD
XFE_PHC23_bus_wbuf_49 DEL2 $PINS I=bus_wbuf<49> Z=FE_PHN23_bus_wbuf_49 VSS=DVSS
+ VDD=DVDD
XFE_PHC22_bus_wbuf_48 DEL2 $PINS I=bus_wbuf<48> Z=FE_PHN22_bus_wbuf_48 VSS=DVSS
+ VDD=DVDD
XFE_PHC21_rstn DEL1 $PINS I=rstn Z=FE_PHN21_rstn VSS=DVSS VDD=DVDD
XFE_PHC20_bus_addr_3 DEL1 $PINS I=FE_PHN342_bus_addr_3 Z=FE_PHN20_bus_addr_3
+ VSS=DVSS VDD=DVDD
XFE_PHC19_bus_addr_4 DEL1 $PINS I=FE_PHN319_bus_addr_4 Z=FE_PHN19_bus_addr_4
+ VSS=DVSS VDD=DVDD
XFE_PHC18_bus_addr_5 DEL1 $PINS I=FE_PHN320_bus_addr_5 Z=FE_PHN18_bus_addr_5
+ VSS=DVSS VDD=DVDD
XFE_PHC17_bus_addr_6 DEL1 $PINS I=FE_PHN341_bus_addr_6 Z=FE_PHN17_bus_addr_6
+ VSS=DVSS VDD=DVDD
XFE_PHC16_bus_addr_7 DEL1 $PINS I=FE_PHN344_bus_addr_7 Z=FE_PHN16_bus_addr_7
+ VSS=DVSS VDD=DVDD
XFE_PHC15_tpu_re DEL0 $PINS I=tpu_re Z=FE_PHN15_tpu_re VSS=DVSS VDD=DVDD
XFE_PHC14_bus_we DEL1 $PINS I=bus_we Z=FE_PHN14_bus_we VSS=DVSS VDD=DVDD
XFE_PHC13_bus_addr_0 DEL1 $PINS I=bus_addr<0> Z=FE_PHN13_bus_addr_0 VSS=DVSS
+ VDD=DVDD
XFE_PHC12_bus_addr_1 DEL0 $PINS I=bus_addr<1> Z=FE_PHN12_bus_addr_1 VSS=DVSS
+ VDD=DVDD
XCTS_ccl_a_inv_00009 CKND2 $PINS I=CTS_8 ZN=CTS_7 VSS=DVSS VDD=DVDD
XCTS_ccl_a_inv_00008 CKND2 $PINS I=CTS_8 ZN=CTS_6 VSS=DVSS VDD=DVDD
XCTS_ccl_a_inv_00007 CKND2 $PINS I=CTS_8 ZN=CTS_5 VSS=DVSS VDD=DVDD
XCTS_ccl_a_inv_00006 CKND2 $PINS I=CTS_8 ZN=CTS_4 VSS=DVSS VDD=DVDD
XCTS_ccl_a_inv_00005 CKND3 $PINS I=CTS_8 ZN=CTS_3 VSS=DVSS VDD=DVDD
XCTS_ccl_a_inv_00004 CKND2 $PINS I=CTS_8 ZN=CTS_2 VSS=DVSS VDD=DVDD
XCTS_ccl_a_inv_00003 CKND2 $PINS I=CTS_8 ZN=CTS_1 VSS=DVSS VDD=DVDD
XCTS_ccl_a_inv_00002 CKND2 $PINS I=CTS_8 ZN=CTS_10 VSS=DVSS VDD=DVDD
XCTS_ccl_a_inv_00001 CKND2 $PINS I=CTS_8 ZN=CTS_9 VSS=DVSS VDD=DVDD
XCTS_ccl_a_inv_00010 CKND6 $PINS I=CTS_11 ZN=CTS_8 VSS=DVSS VDD=DVDD
XCTS_ccl_a_inv_00011 CKND3 $PINS I=CTS_12 ZN=CTS_11 VSS=DVSS VDD=DVDD
XCTS_cmf_inv_00057 CKND1 $PINS I=clk ZN=CTS_12 VSS=DVSS VDD=DVDD
XLTIELO TIEL $PINS ZN=LTIELO_NET VSS=DVSS VDD=DVDD
XLTIEHI TIEH $PINS Z=LTIEHI_NET VSS=DVSS VDD=DVDD
XFE_OFC11_sram_addr_0 CKBD1 $PINS I=sram_addr<0> Z=FE_OFN11_sram_addr_0
+ VSS=DVSS VDD=DVDD
XFE_OFC10_sram_addr_1 CKBD1 $PINS I=sram_addr<1> Z=FE_OFN10_sram_addr_1
+ VSS=DVSS VDD=DVDD
XFE_OFC9_sram_addr_2 CKBD1 $PINS I=sram_addr<2> Z=FE_OFN9_sram_addr_2 VSS=DVSS
+ VDD=DVDD
XFE_OFC8_sram_addr_3 CKBD1 $PINS I=sram_addr<3> Z=FE_OFN8_sram_addr_3 VSS=DVSS
+ VDD=DVDD
XFE_OFC7_sram_addr_4 CKBD1 $PINS I=sram_addr<4> Z=FE_OFN7_sram_addr_4 VSS=DVSS
+ VDD=DVDD
XFE_OFC6_sram_addr_5 CKBD1 $PINS I=sram_addr<5> Z=FE_OFN6_sram_addr_5 VSS=DVSS
+ VDD=DVDD
XFE_OFC5_sram_addr_6 CKBD1 $PINS I=sram_addr<6> Z=FE_OFN5_sram_addr_6 VSS=DVSS
+ VDD=DVDD
XFE_OFC4_sram_addr_7 CKBD1 $PINS I=sram_addr<7> Z=FE_OFN4_sram_addr_7 VSS=DVSS
+ VDD=DVDD
XFE_OFC3_sram_addr_8 CKBD1 $PINS I=sram_addr<8> Z=FE_OFN3_sram_addr_8 VSS=DVSS
+ VDD=DVDD
XFE_OFC2_bus_we_d1 BUFFD2 $PINS I=bus_we_d1 Z=FE_OFN2_bus_we_d1 VSS=DVSS
+ VDD=DVDD
XFE_OFC1_tpu_re CKBD1 $PINS I=FE_PHN239_tpu_re Z=FE_OFN1_tpu_re VSS=DVSS
+ VDD=DVDD
XFE_OFC0_rstn CKBD1 $PINS I=FE_PHN21_rstn Z=FE_OFN0_rstn VSS=DVSS VDD=DVDD
Xu_sram sram00 $PINS Q<63>=FE_PHN65_tpu_dout_63 Q<62>=FE_PHN81_tpu_dout_62
+ Q<61>=FE_PHN57_tpu_dout_61 Q<60>=FE_PHN93_tpu_dout_60
+ Q<59>=FE_PHN109_tpu_dout_59 Q<58>=FE_PHN79_tpu_dout_58
+ Q<57>=FE_PHN55_tpu_dout_57 Q<56>=FE_PHN111_tpu_dout_56
+ Q<55>=FE_PHN77_tpu_dout_55 Q<54>=FE_PHN59_tpu_dout_54
+ Q<53>=FE_PHN53_tpu_dout_53 Q<52>=FE_PHN91_tpu_dout_52
+ Q<51>=FE_PHN51_tpu_dout_51 Q<50>=FE_PHN49_tpu_dout_50
+ Q<49>=FE_PHN63_tpu_dout_49 Q<48>=FE_PHN47_tpu_dout_48
+ Q<47>=FE_PHN107_tpu_dout_47 Q<46>=FE_PHN73_tpu_dout_46
+ Q<45>=FE_PHN119_tpu_dout_45 Q<44>=FE_PHN75_tpu_dout_44
+ Q<43>=FE_PHN45_tpu_dout_43 Q<42>=FE_PHN121_tpu_dout_42
+ Q<41>=FE_PHN69_tpu_dout_41 Q<40>=FE_PHN105_tpu_dout_40
+ Q<39>=FE_PHN71_tpu_dout_39 Q<38>=FE_PHN103_tpu_dout_38
+ Q<37>=FE_PHN89_tpu_dout_37 Q<36>=FE_PHN117_tpu_dout_36
+ Q<35>=FE_PHN85_tpu_dout_35 Q<34>=FE_PHN101_tpu_dout_34
+ Q<33>=FE_PHN133_tpu_dout_33 Q<32>=FE_PHN87_tpu_dout_32
+ Q<31>=FE_PHN151_tpu_dout_31 Q<30>=FE_PHN161_tpu_dout_30
+ Q<29>=FE_PHN135_tpu_dout_29 Q<28>=FE_PHN157_tpu_dout_28
+ Q<27>=FE_PHN171_tpu_dout_27 Q<26>=FE_PHN137_tpu_dout_26
+ Q<25>=FE_PHN153_tpu_dout_25 Q<24>=FE_PHN163_tpu_dout_24
+ Q<23>=FE_PHN139_tpu_dout_23 Q<22>=FE_PHN165_tpu_dout_22
+ Q<21>=FE_PHN125_tpu_dout_21 Q<20>=FE_PHN123_tpu_dout_20
+ Q<19>=FE_PHN145_tpu_dout_19 Q<18>=FE_PHN167_tpu_dout_18
+ Q<17>=FE_PHN147_tpu_dout_17 Q<16>=FE_PHN159_tpu_dout_16
+ Q<15>=FE_PHN127_tpu_dout_15 Q<14>=FE_PHN95_tpu_dout_14
+ Q<13>=FE_PHN113_tpu_dout_13 Q<12>=FE_PHN149_tpu_dout_12
+ Q<11>=FE_PHN169_tpu_dout_11 Q<10>=FE_PHN83_tpu_dout_10
+ Q<9>=FE_PHN143_tpu_dout_9 Q<8>=FE_PHN129_tpu_dout_8 Q<7>=FE_PHN131_tpu_dout_7
+ Q<6>=FE_PHN155_tpu_dout_6 Q<5>=FE_PHN115_tpu_dout_5 Q<4>=FE_PHN61_tpu_dout_4
+ Q<3>=FE_PHN67_tpu_dout_3 Q<2>=FE_PHN97_tpu_dout_2 Q<1>=FE_PHN99_tpu_dout_1
+ Q<0>=FE_PHN141_tpu_dout_0 CLK=CTS_3 CEN=sram_cen WEN=sram_wen
+ A<8>=FE_PHN182_FE_OFN3_sram_addr_8 A<7>=FE_PHN206_FE_OFN4_sram_addr_7
+ A<6>=FE_PHN310_FE_OFN5_sram_addr_6 A<5>=FE_PHN311_FE_OFN6_sram_addr_5
+ A<4>=FE_PHN312_FE_OFN7_sram_addr_4 A<3>=FE_PHN313_FE_OFN8_sram_addr_3
+ A<2>=FE_PHN314_FE_OFN9_sram_addr_2 A<1>=FE_PHN347_FE_OFN10_sram_addr_1
+ A<0>=FE_PHN334_FE_OFN11_sram_addr_0 D<63>=sram_din<63> D<62>=sram_din<62>
+ D<61>=sram_din<61> D<60>=sram_din<60> D<59>=sram_din<59> D<58>=sram_din<58>
+ D<57>=sram_din<57> D<56>=sram_din<56> D<55>=sram_din<55> D<54>=sram_din<54>
+ D<53>=sram_din<53> D<52>=sram_din<52> D<51>=sram_din<51> D<50>=sram_din<50>
+ D<49>=sram_din<49> D<48>=sram_din<48> D<47>=sram_din<47> D<46>=sram_din<46>
+ D<45>=sram_din<45> D<44>=sram_din<44> D<43>=sram_din<43> D<42>=sram_din<42>
+ D<41>=sram_din<41> D<40>=sram_din<40> D<39>=sram_din<39> D<38>=sram_din<38>
+ D<37>=sram_din<37> D<36>=sram_din<36> D<35>=sram_din<35> D<34>=sram_din<34>
+ D<33>=sram_din<33> D<32>=sram_din<32> D<31>=sram_din<31> D<30>=sram_din<30>
+ D<29>=sram_din<29> D<28>=sram_din<28> D<27>=sram_din<27> D<26>=sram_din<26>
+ D<25>=sram_din<25> D<24>=sram_din<24> D<23>=sram_din<23> D<22>=sram_din<22>
+ D<21>=sram_din<21> D<20>=sram_din<20> D<19>=sram_din<19> D<18>=sram_din<18>
+ D<17>=sram_din<17> D<16>=sram_din<16> D<15>=sram_din<15> D<14>=sram_din<14>
+ D<13>=sram_din<13> D<12>=sram_din<12> D<11>=sram_din<11> D<10>=sram_din<10>
+ D<9>=sram_din<9> D<8>=sram_din<8> D<7>=sram_din<7> D<6>=sram_din<6>
+ D<5>=sram_din<5> D<4>=sram_din<4> D<3>=sram_din<3> D<2>=sram_din<2>
+ D<1>=sram_din<1> D<0>=sram_din<0> EMA<2>=LTIELO_NET EMA<1>=LTIEHI_NET
+ EMA<0>=LTIELO_NET RETN=LTIEHI_NET VSS=DVSS VDD=DVDD
Xbus_waddr_d1_reg[0] DFCNQD1 $PINS CDN=FE_OFN0_rstn CP=CTS_7
+ D=FE_PHN20_bus_addr_3 Q=bus_waddr_d1<0> VSS=DVSS VDD=DVDD
Xbus_waddr_d1_reg[1] DFCNQD1 $PINS CDN=FE_OFN0_rstn CP=CTS_7
+ D=FE_PHN19_bus_addr_4 Q=bus_waddr_d1<1> VSS=DVSS VDD=DVDD
Xbus_waddr_d1_reg[2] DFCNQD1 $PINS CDN=FE_OFN0_rstn CP=CTS_7
+ D=FE_PHN18_bus_addr_5 Q=bus_waddr_d1<2> VSS=DVSS VDD=DVDD
Xbus_waddr_d1_reg[3] DFCNQD1 $PINS CDN=FE_OFN0_rstn CP=CTS_7
+ D=FE_PHN17_bus_addr_6 Q=bus_waddr_d1<3> VSS=DVSS VDD=DVDD
Xbus_waddr_d1_reg[4] DFCNQD1 $PINS CDN=FE_OFN0_rstn CP=CTS_7
+ D=FE_PHN16_bus_addr_7 Q=bus_waddr_d1<4> VSS=DVSS VDD=DVDD
Xbus_waddr_d1_reg[5] DFCNQD1 $PINS CDN=FE_OFN0_rstn CP=CTS_6
+ D=FE_PHN241_bus_addr_8 Q=bus_waddr_d1<5> VSS=DVSS VDD=DVDD
Xbus_waddr_d1_reg[6] DFCNQD1 $PINS CDN=FE_OFN0_rstn CP=CTS_6
+ D=FE_PHN240_bus_addr_9 Q=bus_waddr_d1<6> VSS=DVSS VDD=DVDD
Xbus_waddr_d1_reg[7] DFCNQD1 $PINS CDN=FE_PHN21_rstn CP=CTS_6
+ D=FE_PHN414_bus_addr_10 Q=bus_waddr_d1<7> VSS=DVSS VDD=DVDD
Xbus_waddr_d1_reg[8] DFCNQD1 $PINS CDN=FE_PHN21_rstn CP=CTS_6
+ D=FE_PHN242_bus_addr_11 Q=bus_waddr_d1<8> VSS=DVSS VDD=DVDD
Xsram_addr_ff_reg[0] DFNCND1 $PINS CDN=FE_OFN0_rstn CPN=CTS_7 D=n_16
+ Q=UNCONNECTED QN=sram_addr_ff<0> VSS=DVSS VDD=DVDD
Xsram_addr_ff_reg[1] DFNCND1 $PINS CDN=FE_OFN0_rstn CPN=CTS_7 D=n_76
+ Q=UNCONNECTED0 QN=sram_addr_ff<1> VSS=DVSS VDD=DVDD
Xsram_addr_ff_reg[2] DFNCND1 $PINS CDN=FE_OFN0_rstn CPN=CTS_7 D=n_50
+ Q=UNCONNECTED1 QN=sram_addr_ff<2> VSS=DVSS VDD=DVDD
Xsram_addr_ff_reg[3] DFNCND1 $PINS CDN=FE_OFN0_rstn CPN=CTS_7 D=n_15
+ Q=UNCONNECTED2 QN=sram_addr_ff<3> VSS=DVSS VDD=DVDD
Xsram_addr_ff_reg[4] DFNCND1 $PINS CDN=FE_OFN0_rstn CPN=CTS_7 D=n_19
+ Q=UNCONNECTED3 QN=sram_addr_ff<4> VSS=DVSS VDD=DVDD
Xsram_addr_ff_reg[5] DFNCND1 $PINS CDN=rstn CPN=CTS_6 D=n_17 Q=UNCONNECTED4
+ QN=sram_addr_ff<5> VSS=DVSS VDD=DVDD
Xsram_addr_ff_reg[6] DFNCND1 $PINS CDN=rstn CPN=CTS_6 D=n_28 Q=UNCONNECTED5
+ QN=sram_addr_ff<6> VSS=DVSS VDD=DVDD
Xsram_addr_ff_reg[7] DFNCND1 $PINS CDN=rstn CPN=CTS_6 D=n_22 Q=UNCONNECTED6
+ QN=sram_addr_ff<7> VSS=DVSS VDD=DVDD
Xsram_addr_ff_reg[8] DFNCND1 $PINS CDN=rstn CPN=CTS_6 D=n_20 Q=UNCONNECTED7
+ QN=sram_addr_ff<8> VSS=DVSS VDD=DVDD
Xsram_din_ff_reg[0] DFNCND1 $PINS CDN=FE_OFN0_rstn CPN=CTS_7 D=n_71
+ Q=UNCONNECTED8 QN=sram_din_ff<0> VSS=DVSS VDD=DVDD
Xsram_din_ff_reg[1] DFNCND1 $PINS CDN=FE_OFN0_rstn CPN=CTS_7 D=n_21
+ Q=UNCONNECTED9 QN=sram_din_ff<1> VSS=DVSS VDD=DVDD
Xsram_din_ff_reg[2] DFNCND1 $PINS CDN=FE_OFN0_rstn CPN=CTS_7 D=n_24
+ Q=UNCONNECTED10 QN=sram_din_ff<2> VSS=DVSS VDD=DVDD
Xsram_din_ff_reg[3] DFNCND1 $PINS CDN=FE_OFN0_rstn CPN=CTS_7 D=n_23
+ Q=UNCONNECTED11 QN=sram_din_ff<3> VSS=DVSS VDD=DVDD
Xsram_din_ff_reg[4] DFNCND1 $PINS CDN=rstn CPN=CTS_6 D=n_69 Q=UNCONNECTED12
+ QN=sram_din_ff<4> VSS=DVSS VDD=DVDD
Xsram_din_ff_reg[5] DFNCND1 $PINS CDN=rstn CPN=CTS_6 D=n_27 Q=UNCONNECTED13
+ QN=sram_din_ff<5> VSS=DVSS VDD=DVDD
Xsram_din_ff_reg[6] DFNCND1 $PINS CDN=rstn CPN=CTS_6 D=n_26 Q=UNCONNECTED14
+ QN=sram_din_ff<6> VSS=DVSS VDD=DVDD
Xsram_din_ff_reg[7] DFNCND1 $PINS CDN=rstn CPN=CTS_5 D=n_25 Q=UNCONNECTED15
+ QN=sram_din_ff<7> VSS=DVSS VDD=DVDD
Xsram_din_ff_reg[8] DFNCND1 $PINS CDN=rstn CPN=CTS_5 D=n_67 Q=UNCONNECTED16
+ QN=sram_din_ff<8> VSS=DVSS VDD=DVDD
Xsram_din_ff_reg[9] DFNCND1 $PINS CDN=rstn CPN=CTS_5 D=n_30 Q=UNCONNECTED17
+ QN=sram_din_ff<9> VSS=DVSS VDD=DVDD
Xsram_din_ff_reg[10] DFNCND1 $PINS CDN=rstn CPN=CTS_5 D=n_68 Q=UNCONNECTED18
+ QN=sram_din_ff<10> VSS=DVSS VDD=DVDD
Xsram_din_ff_reg[11] DFNCND1 $PINS CDN=rstn CPN=CTS_5 D=n_48 Q=UNCONNECTED19
+ QN=sram_din_ff<11> VSS=DVSS VDD=DVDD
Xsram_din_ff_reg[12] DFNCND1 $PINS CDN=rstn CPN=CTS_5 D=n_64 Q=UNCONNECTED20
+ QN=sram_din_ff<12> VSS=DVSS VDD=DVDD
Xsram_din_ff_reg[13] DFNCND1 $PINS CDN=rstn CPN=CTS_5 D=n_33 Q=UNCONNECTED21
+ QN=sram_din_ff<13> VSS=DVSS VDD=DVDD
Xsram_din_ff_reg[14] DFNCND1 $PINS CDN=rstn CPN=CTS_5 D=n_31 Q=UNCONNECTED22
+ QN=sram_din_ff<14> VSS=DVSS VDD=DVDD
Xsram_din_ff_reg[15] DFNCND1 $PINS CDN=rstn CPN=CTS_4 D=n_32 Q=UNCONNECTED23
+ QN=sram_din_ff<15> VSS=DVSS VDD=DVDD
Xsram_din_ff_reg[16] DFNCND1 $PINS CDN=rstn CPN=CTS_4 D=n_61 Q=UNCONNECTED24
+ QN=sram_din_ff<16> VSS=DVSS VDD=DVDD
Xsram_din_ff_reg[17] DFNCND1 $PINS CDN=rstn CPN=CTS_4 D=n_58 Q=UNCONNECTED25
+ QN=sram_din_ff<17> VSS=DVSS VDD=DVDD
Xsram_din_ff_reg[18] DFNCND1 $PINS CDN=rstn CPN=CTS_4 D=n_44 Q=UNCONNECTED26
+ QN=sram_din_ff<18> VSS=DVSS VDD=DVDD
Xsram_din_ff_reg[19] DFNCND1 $PINS CDN=rstn CPN=CTS_4 D=n_40 Q=UNCONNECTED27
+ QN=sram_din_ff<19> VSS=DVSS VDD=DVDD
Xsram_din_ff_reg[20] DFNCND1 $PINS CDN=rstn CPN=CTS_4 D=n_36 Q=UNCONNECTED28
+ QN=sram_din_ff<20> VSS=DVSS VDD=DVDD
Xsram_din_ff_reg[21] DFNCND1 $PINS CDN=rstn CPN=CTS_4 D=n_34 Q=UNCONNECTED29
+ QN=sram_din_ff<21> VSS=DVSS VDD=DVDD
Xsram_din_ff_reg[22] DFNCND1 $PINS CDN=rstn CPN=CTS_4 D=n_35 Q=UNCONNECTED30
+ QN=sram_din_ff<22> VSS=DVSS VDD=DVDD
Xsram_din_ff_reg[23] DFNCND1 $PINS CDN=rstn CPN=CTS_4 D=n_38 Q=UNCONNECTED31
+ QN=sram_din_ff<23> VSS=DVSS VDD=DVDD
Xsram_din_ff_reg[24] DFNCND1 $PINS CDN=rstn CPN=CTS_9 D=n_37 Q=UNCONNECTED32
+ QN=sram_din_ff<24> VSS=DVSS VDD=DVDD
Xsram_din_ff_reg[25] DFNCND1 $PINS CDN=rstn CPN=CTS_9 D=n_47 Q=UNCONNECTED33
+ QN=sram_din_ff<25> VSS=DVSS VDD=DVDD
Xsram_din_ff_reg[26] DFNCND1 $PINS CDN=rstn CPN=CTS_9 D=n_43 Q=UNCONNECTED34
+ QN=sram_din_ff<26> VSS=DVSS VDD=DVDD
Xsram_din_ff_reg[27] DFNCND1 $PINS CDN=rstn CPN=CTS_9 D=n_41 Q=UNCONNECTED35
+ QN=sram_din_ff<27> VSS=DVSS VDD=DVDD
Xsram_din_ff_reg[28] DFNCND1 $PINS CDN=rstn CPN=CTS_9 D=n_62 Q=UNCONNECTED36
+ QN=sram_din_ff<28> VSS=DVSS VDD=DVDD
Xsram_din_ff_reg[29] DFNCND1 $PINS CDN=rstn CPN=CTS_9 D=n_45 Q=UNCONNECTED37
+ QN=sram_din_ff<29> VSS=DVSS VDD=DVDD
Xsram_din_ff_reg[30] DFNCND1 $PINS CDN=rstn CPN=CTS_9 D=n_83 Q=UNCONNECTED38
+ QN=sram_din_ff<30> VSS=DVSS VDD=DVDD
Xsram_din_ff_reg[31] DFNCND1 $PINS CDN=rstn CPN=CTS_9 D=n_65 Q=UNCONNECTED39
+ QN=sram_din_ff<31> VSS=DVSS VDD=DVDD
Xsram_din_ff_reg[32] DFNCND1 $PINS CDN=rstn CPN=CTS_3 D=n_55 Q=UNCONNECTED40
+ QN=sram_din_ff<32> VSS=DVSS VDD=DVDD
Xsram_din_ff_reg[33] DFNCND1 $PINS CDN=rstn CPN=CTS_3 D=n_14 Q=UNCONNECTED41
+ QN=sram_din_ff<33> VSS=DVSS VDD=DVDD
Xsram_din_ff_reg[34] DFNCND1 $PINS CDN=rstn CPN=CTS_3 D=n_49 Q=UNCONNECTED42
+ QN=sram_din_ff<34> VSS=DVSS VDD=DVDD
Xsram_din_ff_reg[35] DFNCND1 $PINS CDN=rstn CPN=CTS_3 D=n_51 Q=UNCONNECTED43
+ QN=sram_din_ff<35> VSS=DVSS VDD=DVDD
Xsram_din_ff_reg[36] DFNCND1 $PINS CDN=rstn CPN=CTS_2 D=n_53 Q=UNCONNECTED44
+ QN=sram_din_ff<36> VSS=DVSS VDD=DVDD
Xsram_din_ff_reg[37] DFNCND1 $PINS CDN=rstn CPN=CTS_2 D=n_52 Q=UNCONNECTED45
+ QN=sram_din_ff<37> VSS=DVSS VDD=DVDD
Xsram_din_ff_reg[38] DFNCND1 $PINS CDN=rstn CPN=CTS_2 D=n_54 Q=UNCONNECTED46
+ QN=sram_din_ff<38> VSS=DVSS VDD=DVDD
Xsram_din_ff_reg[39] DFNCND1 $PINS CDN=rstn CPN=CTS_2 D=n_63 Q=UNCONNECTED47
+ QN=sram_din_ff<39> VSS=DVSS VDD=DVDD
Xsram_din_ff_reg[40] DFNCND1 $PINS CDN=rstn CPN=CTS_2 D=n_46 Q=UNCONNECTED48
+ QN=sram_din_ff<40> VSS=DVSS VDD=DVDD
Xsram_din_ff_reg[41] DFNCND1 $PINS CDN=rstn CPN=CTS_2 D=n_56 Q=UNCONNECTED49
+ QN=sram_din_ff<41> VSS=DVSS VDD=DVDD
Xsram_din_ff_reg[42] DFNCND1 $PINS CDN=rstn CPN=CTS_2 D=n_57 Q=UNCONNECTED50
+ QN=sram_din_ff<42> VSS=DVSS VDD=DVDD
Xsram_din_ff_reg[43] DFNCND1 $PINS CDN=rstn CPN=CTS_2 D=n_86 Q=UNCONNECTED51
+ QN=sram_din_ff<43> VSS=DVSS VDD=DVDD
Xsram_din_ff_reg[44] DFNCND1 $PINS CDN=rstn CPN=CTS_2 D=n_59 Q=UNCONNECTED52
+ QN=sram_din_ff<44> VSS=DVSS VDD=DVDD
Xsram_din_ff_reg[45] DFNCND1 $PINS CDN=rstn CPN=CTS_2 D=n_81 Q=UNCONNECTED53
+ QN=sram_din_ff<45> VSS=DVSS VDD=DVDD
Xsram_din_ff_reg[46] DFNCND1 $PINS CDN=rstn CPN=CTS_1 D=n_73 Q=UNCONNECTED54
+ QN=sram_din_ff<46> VSS=DVSS VDD=DVDD
Xsram_din_ff_reg[47] DFNCND1 $PINS CDN=rstn CPN=CTS_1 D=n_72 Q=UNCONNECTED55
+ QN=sram_din_ff<47> VSS=DVSS VDD=DVDD
Xsram_din_ff_reg[48] DFNCND1 $PINS CDN=rstn CPN=CTS_1 D=n_42 Q=UNCONNECTED56
+ QN=sram_din_ff<48> VSS=DVSS VDD=DVDD
Xsram_din_ff_reg[49] DFNCND1 $PINS CDN=rstn CPN=CTS_1 D=n_70 Q=UNCONNECTED57
+ QN=sram_din_ff<49> VSS=DVSS VDD=DVDD
Xsram_din_ff_reg[50] DFNCND1 $PINS CDN=rstn CPN=CTS_1 D=n_77 Q=UNCONNECTED58
+ QN=sram_din_ff<50> VSS=DVSS VDD=DVDD
Xsram_din_ff_reg[51] DFNCND1 $PINS CDN=rstn CPN=CTS_1 D=n_74 Q=UNCONNECTED59
+ QN=sram_din_ff<51> VSS=DVSS VDD=DVDD
Xsram_din_ff_reg[52] DFNCND1 $PINS CDN=rstn CPN=CTS_1 D=n_75 Q=UNCONNECTED60
+ QN=sram_din_ff<52> VSS=DVSS VDD=DVDD
Xsram_din_ff_reg[53] DFNCND1 $PINS CDN=rstn CPN=CTS_10 D=n_85 Q=UNCONNECTED61
+ QN=sram_din_ff<53> VSS=DVSS VDD=DVDD
Xsram_din_ff_reg[54] DFNCND1 $PINS CDN=rstn CPN=CTS_10 D=n_79 Q=UNCONNECTED62
+ QN=sram_din_ff<54> VSS=DVSS VDD=DVDD
Xsram_din_ff_reg[55] DFNCND1 $PINS CDN=rstn CPN=CTS_10 D=n_78 Q=UNCONNECTED63
+ QN=sram_din_ff<55> VSS=DVSS VDD=DVDD
Xsram_din_ff_reg[56] DFNCND1 $PINS CDN=rstn CPN=CTS_10 D=n_39 Q=UNCONNECTED64
+ QN=sram_din_ff<56> VSS=DVSS VDD=DVDD
Xsram_din_ff_reg[57] DFNCND1 $PINS CDN=rstn CPN=CTS_10 D=n_18 Q=UNCONNECTED65
+ QN=sram_din_ff<57> VSS=DVSS VDD=DVDD
Xsram_din_ff_reg[58] DFNCND1 $PINS CDN=rstn CPN=CTS_10 D=n_29 Q=UNCONNECTED66
+ QN=sram_din_ff<58> VSS=DVSS VDD=DVDD
Xsram_din_ff_reg[59] DFNCND1 $PINS CDN=rstn CPN=CTS_10 D=n_80 Q=UNCONNECTED67
+ QN=sram_din_ff<59> VSS=DVSS VDD=DVDD
Xsram_din_ff_reg[60] DFNCND1 $PINS CDN=rstn CPN=CTS_10 D=n_60 Q=UNCONNECTED68
+ QN=sram_din_ff<60> VSS=DVSS VDD=DVDD
Xsram_din_ff_reg[61] DFNCND1 $PINS CDN=rstn CPN=CTS_10 D=n_84 Q=UNCONNECTED69
+ QN=sram_din_ff<61> VSS=DVSS VDD=DVDD
Xsram_din_ff_reg[62] DFNCND1 $PINS CDN=rstn CPN=CTS_10 D=n_66 Q=UNCONNECTED70
+ QN=sram_din_ff<62> VSS=DVSS VDD=DVDD
Xsram_din_ff_reg[63] DFNCND1 $PINS CDN=rstn CPN=CTS_10 D=n_82 Q=UNCONNECTED71
+ QN=sram_din_ff<63> VSS=DVSS VDD=DVDD
Xp11362A__2398 MOAI22D0 $PINS A1=FE_PHN15_tpu_re A2=sram_addr_ff<5>
+ B1=FE_PHN15_tpu_re B2=tpu_addr<5> ZN=sram_addr<5> VSS=DVSS VDD=DVDD
Xp11362A3056__5107 MOAI22D0 $PINS A1=FE_PHN15_tpu_re A2=sram_addr_ff<7>
+ B1=FE_PHN15_tpu_re B2=FE_PHN321_tpu_addr_7 ZN=sram_addr<7> VSS=DVSS VDD=DVDD
Xp11362A3057__6260 MOAI22D0 $PINS A1=FE_PHN15_tpu_re A2=sram_addr_ff<8>
+ B1=FE_PHN15_tpu_re B2=FE_PHN297_tpu_addr_8 ZN=sram_addr<8> VSS=DVSS VDD=DVDD
Xp11362A3058__4319 MOAI22D0 $PINS A1=FE_PHN15_tpu_re A2=sram_addr_ff<2>
+ B1=FE_PHN15_tpu_re B2=tpu_addr<2> ZN=sram_addr<2> VSS=DVSS VDD=DVDD
Xp11362A3059__8428 MOAI22D0 $PINS A1=FE_PHN15_tpu_re A2=sram_addr_ff<6>
+ B1=FE_PHN15_tpu_re B2=tpu_addr<6> ZN=sram_addr<6> VSS=DVSS VDD=DVDD
Xp11362A3060__5526 MOAI22D0 $PINS A1=FE_PHN239_tpu_re A2=sram_addr_ff<0>
+ B1=FE_PHN239_tpu_re B2=tpu_addr<0> ZN=sram_addr<0> VSS=DVSS VDD=DVDD
Xp11362A3061__6783 MOAI22D0 $PINS A1=FE_PHN239_tpu_re A2=sram_addr_ff<1>
+ B1=FE_PHN239_tpu_re B2=tpu_addr<1> ZN=sram_addr<1> VSS=DVSS VDD=DVDD
Xp11362A3062__3680 MOAI22D0 $PINS A1=FE_PHN15_tpu_re A2=sram_addr_ff<4>
+ B1=FE_PHN15_tpu_re B2=tpu_addr<4> ZN=sram_addr<4> VSS=DVSS VDD=DVDD
Xp11362A3063__1617 MOAI22D0 $PINS A1=FE_PHN15_tpu_re A2=sram_addr_ff<3>
+ B1=FE_PHN15_tpu_re B2=tpu_addr<3> ZN=sram_addr<3> VSS=DVSS VDD=DVDD
Xp11608A__2802 NR2D0 $PINS A1=FE_PHN239_tpu_re A2=sram_din_ff<13>
+ ZN=sram_din<13> VSS=DVSS VDD=DVDD
Xp11608A3064__1705 NR2D0 $PINS A1=FE_PHN239_tpu_re A2=sram_din_ff<23>
+ ZN=sram_din<23> VSS=DVSS VDD=DVDD
Xp11608A3065__5122 NR2D0 $PINS A1=FE_PHN239_tpu_re A2=sram_din_ff<22>
+ ZN=sram_din<22> VSS=DVSS VDD=DVDD
Xp11608A3066__8246 NR2D0 $PINS A1=FE_OFN1_tpu_re A2=sram_din_ff<54>
+ ZN=sram_din<54> VSS=DVSS VDD=DVDD
Xp11608A3067__7098 NR2D0 $PINS A1=FE_PHN239_tpu_re A2=sram_din_ff<21>
+ ZN=sram_din<21> VSS=DVSS VDD=DVDD
Xp11608A3068__6131 NR2D0 $PINS A1=FE_PHN239_tpu_re A2=sram_din_ff<20>
+ ZN=sram_din<20> VSS=DVSS VDD=DVDD
Xp11608A3069__1881 NR2D0 $PINS A1=FE_OFN1_tpu_re A2=sram_din_ff<53>
+ ZN=sram_din<53> VSS=DVSS VDD=DVDD
Xp11608A3070__5115 NR2D0 $PINS A1=FE_PHN239_tpu_re A2=sram_din_ff<19>
+ ZN=sram_din<19> VSS=DVSS VDD=DVDD
Xp11608A3071__7482 NR2D0 $PINS A1=FE_PHN239_tpu_re A2=sram_din_ff<18>
+ ZN=sram_din<18> VSS=DVSS VDD=DVDD
Xp11608A3072__4733 NR2D0 $PINS A1=FE_OFN1_tpu_re A2=sram_din_ff<52>
+ ZN=sram_din<52> VSS=DVSS VDD=DVDD
Xp11608A3073__6161 NR2D0 $PINS A1=FE_PHN239_tpu_re A2=sram_din_ff<17>
+ ZN=sram_din<17> VSS=DVSS VDD=DVDD
Xp11608A3074__9315 NR2D0 $PINS A1=FE_PHN239_tpu_re A2=sram_din_ff<16>
+ ZN=sram_din<16> VSS=DVSS VDD=DVDD
Xp11608A3075__9945 NR2D0 $PINS A1=FE_OFN1_tpu_re A2=sram_din_ff<51>
+ ZN=sram_din<51> VSS=DVSS VDD=DVDD
Xp11608A3076__2883 NR2D0 $PINS A1=FE_PHN239_tpu_re A2=sram_din_ff<15>
+ ZN=sram_din<15> VSS=DVSS VDD=DVDD
Xp11608A3077__2346 NR2D0 $PINS A1=FE_PHN239_tpu_re A2=sram_din_ff<14>
+ ZN=sram_din<14> VSS=DVSS VDD=DVDD
Xp11608A3078__1666 NR2D0 $PINS A1=FE_OFN1_tpu_re A2=sram_din_ff<50>
+ ZN=sram_din<50> VSS=DVSS VDD=DVDD
Xp11608A3079__7410 NR2D0 $PINS A1=FE_OFN1_tpu_re A2=sram_din_ff<55>
+ ZN=sram_din<55> VSS=DVSS VDD=DVDD
Xp11608A3080__6417 NR2D0 $PINS A1=FE_PHN239_tpu_re A2=sram_din_ff<12>
+ ZN=sram_din<12> VSS=DVSS VDD=DVDD
Xp11608A3081__5477 NR2D0 $PINS A1=FE_OFN1_tpu_re A2=sram_din_ff<49>
+ ZN=sram_din<49> VSS=DVSS VDD=DVDD
Xp11608A3082__2398 NR2D0 $PINS A1=FE_PHN239_tpu_re A2=sram_din_ff<11>
+ ZN=sram_din<11> VSS=DVSS VDD=DVDD
Xp11608A3083__5107 NR2D0 $PINS A1=FE_PHN239_tpu_re A2=sram_din_ff<10>
+ ZN=sram_din<10> VSS=DVSS VDD=DVDD
Xp11608A3084__6260 NR2D0 $PINS A1=FE_OFN1_tpu_re A2=sram_din_ff<48>
+ ZN=sram_din<48> VSS=DVSS VDD=DVDD
Xp11608A3085__4319 NR2D0 $PINS A1=FE_PHN239_tpu_re A2=sram_din_ff<9>
+ ZN=sram_din<9> VSS=DVSS VDD=DVDD
Xp11608A3086__8428 NR2D0 $PINS A1=FE_PHN239_tpu_re A2=sram_din_ff<8>
+ ZN=sram_din<8> VSS=DVSS VDD=DVDD
Xp11608A3087__5526 NR2D0 $PINS A1=FE_OFN1_tpu_re A2=sram_din_ff<47>
+ ZN=sram_din<47> VSS=DVSS VDD=DVDD
Xp11608A3088__6783 NR2D0 $PINS A1=FE_PHN239_tpu_re A2=sram_din_ff<7>
+ ZN=sram_din<7> VSS=DVSS VDD=DVDD
Xp11608A3089__3680 NR2D0 $PINS A1=FE_PHN239_tpu_re A2=sram_din_ff<6>
+ ZN=sram_din<6> VSS=DVSS VDD=DVDD
Xp11608A3090__1617 NR2D0 $PINS A1=FE_OFN1_tpu_re A2=sram_din_ff<46>
+ ZN=sram_din<46> VSS=DVSS VDD=DVDD
Xp11608A3091__2802 NR2D0 $PINS A1=FE_PHN239_tpu_re A2=sram_din_ff<5>
+ ZN=sram_din<5> VSS=DVSS VDD=DVDD
Xp11608A3092__1705 NR2D0 $PINS A1=FE_PHN239_tpu_re A2=sram_din_ff<4>
+ ZN=sram_din<4> VSS=DVSS VDD=DVDD
Xp11608A3093__5122 NR2D0 $PINS A1=FE_OFN1_tpu_re A2=sram_din_ff<45>
+ ZN=sram_din<45> VSS=DVSS VDD=DVDD
Xp11608A3094__8246 NR2D0 $PINS A1=FE_PHN239_tpu_re A2=sram_din_ff<3>
+ ZN=sram_din<3> VSS=DVSS VDD=DVDD
Xp11608A3095__7098 NR2D0 $PINS A1=FE_OFN1_tpu_re A2=sram_din_ff<34>
+ ZN=sram_din<34> VSS=DVSS VDD=DVDD
Xp11608A3096__6131 NR2D0 $PINS A1=FE_OFN1_tpu_re A2=sram_din_ff<44>
+ ZN=sram_din<44> VSS=DVSS VDD=DVDD
Xp11608A3097__1881 NR2D0 $PINS A1=FE_PHN239_tpu_re A2=sram_din_ff<1>
+ ZN=sram_din<1> VSS=DVSS VDD=DVDD
Xp11608A3098__5115 NR2D0 $PINS A1=FE_PHN239_tpu_re A2=sram_din_ff<0>
+ ZN=sram_din<0> VSS=DVSS VDD=DVDD
Xp11608A3099__7482 NR2D0 $PINS A1=FE_OFN1_tpu_re A2=sram_din_ff<43>
+ ZN=sram_din<43> VSS=DVSS VDD=DVDD
Xp11608A3100__4733 NR2D0 $PINS A1=FE_OFN1_tpu_re A2=sram_din_ff<42>
+ ZN=sram_din<42> VSS=DVSS VDD=DVDD
Xp11608A3101__6161 NR2D0 $PINS A1=FE_OFN1_tpu_re A2=sram_din_ff<41>
+ ZN=sram_din<41> VSS=DVSS VDD=DVDD
Xp11608A3102__9315 NR2D0 $PINS A1=FE_OFN1_tpu_re A2=sram_din_ff<40>
+ ZN=sram_din<40> VSS=DVSS VDD=DVDD
Xp11608A3103__9945 NR2D0 $PINS A1=FE_OFN1_tpu_re A2=sram_din_ff<63>
+ ZN=sram_din<63> VSS=DVSS VDD=DVDD
Xp11608A3104__2883 NR2D0 $PINS A1=FE_OFN1_tpu_re A2=sram_din_ff<39>
+ ZN=sram_din<39> VSS=DVSS VDD=DVDD
Xp11608A3105__2346 NR2D0 $PINS A1=FE_OFN1_tpu_re A2=sram_din_ff<38>
+ ZN=sram_din<38> VSS=DVSS VDD=DVDD
Xp11608A3106__1666 NR2D0 $PINS A1=FE_OFN1_tpu_re A2=sram_din_ff<62>
+ ZN=sram_din<62> VSS=DVSS VDD=DVDD
Xp11608A3107__7410 NR2D0 $PINS A1=FE_OFN1_tpu_re A2=sram_din_ff<37>
+ ZN=sram_din<37> VSS=DVSS VDD=DVDD
Xp11608A3108__6417 NR2D0 $PINS A1=FE_OFN1_tpu_re A2=sram_din_ff<36>
+ ZN=sram_din<36> VSS=DVSS VDD=DVDD
Xp11608A3109__5477 NR2D0 $PINS A1=FE_OFN1_tpu_re A2=sram_din_ff<61>
+ ZN=sram_din<61> VSS=DVSS VDD=DVDD
Xp11608A3110__2398 NR2D0 $PINS A1=FE_OFN1_tpu_re A2=sram_din_ff<35>
+ ZN=sram_din<35> VSS=DVSS VDD=DVDD
Xp11608A3111__5107 NR2D0 $PINS A1=FE_PHN239_tpu_re A2=sram_din_ff<2>
+ ZN=sram_din<2> VSS=DVSS VDD=DVDD
Xp11608A3112__6260 NR2D0 $PINS A1=FE_OFN1_tpu_re A2=sram_din_ff<60>
+ ZN=sram_din<60> VSS=DVSS VDD=DVDD
Xp11608A3113__4319 NR2D0 $PINS A1=FE_OFN1_tpu_re A2=sram_din_ff<33>
+ ZN=sram_din<33> VSS=DVSS VDD=DVDD
Xp11608A3114__8428 NR2D0 $PINS A1=FE_OFN1_tpu_re A2=sram_din_ff<32>
+ ZN=sram_din<32> VSS=DVSS VDD=DVDD
Xp11608A3115__5526 NR2D0 $PINS A1=FE_OFN1_tpu_re A2=sram_din_ff<59>
+ ZN=sram_din<59> VSS=DVSS VDD=DVDD
Xp11608A3116__6783 NR2D0 $PINS A1=FE_OFN1_tpu_re A2=sram_din_ff<31>
+ ZN=sram_din<31> VSS=DVSS VDD=DVDD
Xp11608A3117__3680 NR2D0 $PINS A1=FE_OFN1_tpu_re A2=sram_din_ff<30>
+ ZN=sram_din<30> VSS=DVSS VDD=DVDD
Xp11608A3118__1617 NR2D0 $PINS A1=FE_OFN1_tpu_re A2=sram_din_ff<58>
+ ZN=sram_din<58> VSS=DVSS VDD=DVDD
Xp11608A3119__2802 NR2D0 $PINS A1=FE_PHN239_tpu_re A2=sram_din_ff<29>
+ ZN=sram_din<29> VSS=DVSS VDD=DVDD
Xp11608A3120__1705 NR2D0 $PINS A1=FE_PHN239_tpu_re A2=sram_din_ff<28>
+ ZN=sram_din<28> VSS=DVSS VDD=DVDD
Xp11608A3121__5122 NR2D0 $PINS A1=FE_OFN1_tpu_re A2=sram_din_ff<57>
+ ZN=sram_din<57> VSS=DVSS VDD=DVDD
Xp11608A3122__8246 NR2D0 $PINS A1=FE_PHN239_tpu_re A2=sram_din_ff<27>
+ ZN=sram_din<27> VSS=DVSS VDD=DVDD
Xp11608A3123__7098 NR2D0 $PINS A1=FE_PHN239_tpu_re A2=sram_din_ff<26>
+ ZN=sram_din<26> VSS=DVSS VDD=DVDD
Xp11608A3124__6131 NR2D0 $PINS A1=FE_OFN1_tpu_re A2=sram_din_ff<56>
+ ZN=sram_din<56> VSS=DVSS VDD=DVDD
Xp11608A3125__1881 NR2D0 $PINS A1=FE_PHN239_tpu_re A2=sram_din_ff<25>
+ ZN=sram_din<25> VSS=DVSS VDD=DVDD
Xp11608A3126__5115 NR2D0 $PINS A1=FE_PHN239_tpu_re A2=sram_din_ff<24>
+ ZN=sram_din<24> VSS=DVSS VDD=DVDD
Xp11422A__7482 CKAN2D0 $PINS A1=bus_wbuf<43> A2=FE_OFN2_bus_we_d1 Z=n_86
+ VSS=DVSS VDD=DVDD
Xp11422A3200__4733 CKAN2D0 $PINS A1=bus_wbuf<53> A2=FE_OFN2_bus_we_d1 Z=n_85
+ VSS=DVSS VDD=DVDD
Xp11422A3201__6161 CKAN2D0 $PINS A1=bus_wbuf<61> A2=FE_OFN2_bus_we_d1 Z=n_84
+ VSS=DVSS VDD=DVDD
Xp11422A3202__9315 CKAN2D0 $PINS A1=bus_wbuf<30> A2=FE_OFN2_bus_we_d1 Z=n_83
+ VSS=DVSS VDD=DVDD
Xp11422A3203__9945 CKAN2D0 $PINS A1=bus_wbuf<63> A2=FE_OFN2_bus_we_d1 Z=n_82
+ VSS=DVSS VDD=DVDD
Xp11422A3204__2883 CKAN2D0 $PINS A1=bus_wbuf<45> A2=FE_OFN2_bus_we_d1 Z=n_81
+ VSS=DVSS VDD=DVDD
Xp11422A3205__2346 CKAN2D0 $PINS A1=bus_wbuf<59> A2=FE_OFN2_bus_we_d1 Z=n_80
+ VSS=DVSS VDD=DVDD
Xp11422A3206__1666 CKAN2D0 $PINS A1=bus_wbuf<54> A2=FE_OFN2_bus_we_d1 Z=n_79
+ VSS=DVSS VDD=DVDD
Xp11422A3207__7410 CKAN2D0 $PINS A1=bus_wbuf<55> A2=FE_OFN2_bus_we_d1 Z=n_78
+ VSS=DVSS VDD=DVDD
Xp11422A3208__6417 CKAN2D0 $PINS A1=bus_wbuf<50> A2=FE_OFN2_bus_we_d1 Z=n_77
+ VSS=DVSS VDD=DVDD
Xp11774A__5477 CKAN2D0 $PINS A1=FE_OFN2_bus_we_d1 A2=bus_waddr_d1<1> Z=n_76
+ VSS=DVSS VDD=DVDD
Xp11422A3209__2398 CKAN2D0 $PINS A1=bus_wbuf<52> A2=FE_OFN2_bus_we_d1 Z=n_75
+ VSS=DVSS VDD=DVDD
Xp11422A3210__5107 CKAN2D0 $PINS A1=bus_wbuf<51> A2=FE_OFN2_bus_we_d1 Z=n_74
+ VSS=DVSS VDD=DVDD
Xp11422A3211__6260 CKAN2D0 $PINS A1=bus_wbuf<46> A2=FE_OFN2_bus_we_d1 Z=n_73
+ VSS=DVSS VDD=DVDD
Xp11422A3212__4319 CKAN2D0 $PINS A1=bus_wbuf<47> A2=FE_OFN2_bus_we_d1 Z=n_72
+ VSS=DVSS VDD=DVDD
Xp11422A3213__8428 CKAN2D0 $PINS A1=bus_wbuf<0> A2=FE_OFN2_bus_we_d1 Z=n_71
+ VSS=DVSS VDD=DVDD
Xp11422A3214__5526 CKAN2D0 $PINS A1=bus_wbuf<49> A2=FE_OFN2_bus_we_d1 Z=n_70
+ VSS=DVSS VDD=DVDD
Xp11422A3215__6783 CKAN2D0 $PINS A1=bus_wbuf<4> A2=FE_OFN2_bus_we_d1 Z=n_69
+ VSS=DVSS VDD=DVDD
Xp11422A3216__3680 CKAN2D0 $PINS A1=bus_wbuf<10> A2=FE_OFN2_bus_we_d1 Z=n_68
+ VSS=DVSS VDD=DVDD
Xp11422A3217__1617 CKAN2D0 $PINS A1=bus_wbuf<8> A2=FE_OFN2_bus_we_d1 Z=n_67
+ VSS=DVSS VDD=DVDD
Xp11422A3218__2802 CKAN2D0 $PINS A1=bus_wbuf<62> A2=FE_OFN2_bus_we_d1 Z=n_66
+ VSS=DVSS VDD=DVDD
Xp11422A3219__1705 CKAN2D0 $PINS A1=bus_wbuf<31> A2=FE_OFN2_bus_we_d1 Z=n_65
+ VSS=DVSS VDD=DVDD
Xp11422A3220__5122 CKAN2D0 $PINS A1=bus_wbuf<12> A2=FE_OFN2_bus_we_d1 Z=n_64
+ VSS=DVSS VDD=DVDD
Xp11422A3221__8246 CKAN2D0 $PINS A1=bus_wbuf<39> A2=FE_OFN2_bus_we_d1 Z=n_63
+ VSS=DVSS VDD=DVDD
Xp11422A3222__7098 CKAN2D0 $PINS A1=bus_wbuf<28> A2=FE_OFN2_bus_we_d1 Z=n_62
+ VSS=DVSS VDD=DVDD
Xp11422A3223__6131 CKAN2D0 $PINS A1=bus_wbuf<16> A2=FE_OFN2_bus_we_d1 Z=n_61
+ VSS=DVSS VDD=DVDD
Xp11422A3224__1881 CKAN2D0 $PINS A1=bus_wbuf<60> A2=FE_OFN2_bus_we_d1 Z=n_60
+ VSS=DVSS VDD=DVDD
Xp11422A3225__5115 CKAN2D0 $PINS A1=bus_wbuf<44> A2=FE_OFN2_bus_we_d1 Z=n_59
+ VSS=DVSS VDD=DVDD
Xp11422A3226__7482 CKAN2D0 $PINS A1=bus_wbuf<17> A2=FE_OFN2_bus_we_d1 Z=n_58
+ VSS=DVSS VDD=DVDD
Xp11422A3227__4733 CKAN2D0 $PINS A1=bus_wbuf<42> A2=FE_OFN2_bus_we_d1 Z=n_57
+ VSS=DVSS VDD=DVDD
Xp11422A3228__6161 CKAN2D0 $PINS A1=bus_wbuf<41> A2=FE_OFN2_bus_we_d1 Z=n_56
+ VSS=DVSS VDD=DVDD
Xp11422A3229__9315 CKAN2D0 $PINS A1=bus_wbuf<32> A2=FE_OFN2_bus_we_d1 Z=n_55
+ VSS=DVSS VDD=DVDD
Xp11422A3230__9945 CKAN2D0 $PINS A1=bus_wbuf<38> A2=FE_OFN2_bus_we_d1 Z=n_54
+ VSS=DVSS VDD=DVDD
Xp11422A3231__2883 CKAN2D0 $PINS A1=bus_wbuf<36> A2=FE_OFN2_bus_we_d1 Z=n_53
+ VSS=DVSS VDD=DVDD
Xp11422A3232__2346 CKAN2D0 $PINS A1=bus_wbuf<37> A2=FE_OFN2_bus_we_d1 Z=n_52
+ VSS=DVSS VDD=DVDD
Xp11422A3233__1666 CKAN2D0 $PINS A1=bus_wbuf<35> A2=FE_OFN2_bus_we_d1 Z=n_51
+ VSS=DVSS VDD=DVDD
Xp11774A3234__7410 CKAN2D0 $PINS A1=FE_OFN2_bus_we_d1 A2=bus_waddr_d1<2> Z=n_50
+ VSS=DVSS VDD=DVDD
Xp11422A3235__6417 CKAN2D0 $PINS A1=bus_wbuf<34> A2=FE_OFN2_bus_we_d1 Z=n_49
+ VSS=DVSS VDD=DVDD
Xp11422A3236__5477 CKAN2D0 $PINS A1=bus_wbuf<11> A2=FE_OFN2_bus_we_d1 Z=n_48
+ VSS=DVSS VDD=DVDD
Xp11422A3237__2398 CKAN2D0 $PINS A1=bus_wbuf<25> A2=FE_OFN2_bus_we_d1 Z=n_47
+ VSS=DVSS VDD=DVDD
Xp11422A3238__5107 CKAN2D0 $PINS A1=bus_wbuf<40> A2=FE_OFN2_bus_we_d1 Z=n_46
+ VSS=DVSS VDD=DVDD
Xp11422A3239__6260 CKAN2D0 $PINS A1=bus_wbuf<29> A2=FE_OFN2_bus_we_d1 Z=n_45
+ VSS=DVSS VDD=DVDD
Xp11422A3240__4319 CKAN2D0 $PINS A1=bus_wbuf<18> A2=FE_OFN2_bus_we_d1 Z=n_44
+ VSS=DVSS VDD=DVDD
Xp11422A3241__8428 CKAN2D0 $PINS A1=bus_wbuf<26> A2=FE_OFN2_bus_we_d1 Z=n_43
+ VSS=DVSS VDD=DVDD
Xp11422A3242__5526 CKAN2D0 $PINS A1=bus_wbuf<48> A2=FE_OFN2_bus_we_d1 Z=n_42
+ VSS=DVSS VDD=DVDD
Xp11422A3243__6783 CKAN2D0 $PINS A1=bus_wbuf<27> A2=FE_OFN2_bus_we_d1 Z=n_41
+ VSS=DVSS VDD=DVDD
Xp11422A3244__3680 CKAN2D0 $PINS A1=bus_wbuf<19> A2=FE_OFN2_bus_we_d1 Z=n_40
+ VSS=DVSS VDD=DVDD
Xp11422A3245__1617 CKAN2D0 $PINS A1=bus_wbuf<56> A2=FE_OFN2_bus_we_d1 Z=n_39
+ VSS=DVSS VDD=DVDD
Xp11422A3246__2802 CKAN2D0 $PINS A1=bus_wbuf<23> A2=FE_OFN2_bus_we_d1 Z=n_38
+ VSS=DVSS VDD=DVDD
Xp11422A3247__1705 CKAN2D0 $PINS A1=bus_wbuf<24> A2=FE_OFN2_bus_we_d1 Z=n_37
+ VSS=DVSS VDD=DVDD
Xp11422A3248__5122 CKAN2D0 $PINS A1=bus_wbuf<20> A2=FE_OFN2_bus_we_d1 Z=n_36
+ VSS=DVSS VDD=DVDD
Xp11422A3249__8246 CKAN2D0 $PINS A1=bus_wbuf<22> A2=FE_OFN2_bus_we_d1 Z=n_35
+ VSS=DVSS VDD=DVDD
Xp11422A3250__7098 CKAN2D0 $PINS A1=bus_wbuf<21> A2=FE_OFN2_bus_we_d1 Z=n_34
+ VSS=DVSS VDD=DVDD
Xp11422A3251__6131 CKAN2D0 $PINS A1=bus_wbuf<13> A2=FE_OFN2_bus_we_d1 Z=n_33
+ VSS=DVSS VDD=DVDD
Xp11422A3252__1881 CKAN2D0 $PINS A1=bus_wbuf<15> A2=FE_OFN2_bus_we_d1 Z=n_32
+ VSS=DVSS VDD=DVDD
Xp11422A3253__5115 CKAN2D0 $PINS A1=bus_wbuf<14> A2=FE_OFN2_bus_we_d1 Z=n_31
+ VSS=DVSS VDD=DVDD
Xp11422A3254__7482 CKAN2D0 $PINS A1=bus_wbuf<9> A2=FE_OFN2_bus_we_d1 Z=n_30
+ VSS=DVSS VDD=DVDD
Xp11422A3255__4733 CKAN2D0 $PINS A1=bus_wbuf<58> A2=FE_OFN2_bus_we_d1 Z=n_29
+ VSS=DVSS VDD=DVDD
Xp11774A3256__6161 CKAN2D0 $PINS A1=FE_OFN2_bus_we_d1 A2=bus_waddr_d1<6> Z=n_28
+ VSS=DVSS VDD=DVDD
Xp11422A3257__9315 CKAN2D0 $PINS A1=bus_wbuf<5> A2=FE_OFN2_bus_we_d1 Z=n_27
+ VSS=DVSS VDD=DVDD
Xp11422A3258__9945 CKAN2D0 $PINS A1=bus_wbuf<6> A2=FE_OFN2_bus_we_d1 Z=n_26
+ VSS=DVSS VDD=DVDD
Xp11422A3259__2883 CKAN2D0 $PINS A1=bus_wbuf<7> A2=FE_OFN2_bus_we_d1 Z=n_25
+ VSS=DVSS VDD=DVDD
Xp11422A3260__2346 CKAN2D0 $PINS A1=bus_wbuf<2> A2=FE_OFN2_bus_we_d1 Z=n_24
+ VSS=DVSS VDD=DVDD
Xp11422A3261__1666 CKAN2D0 $PINS A1=bus_wbuf<3> A2=FE_OFN2_bus_we_d1 Z=n_23
+ VSS=DVSS VDD=DVDD
Xp11774A3262__7410 CKAN2D0 $PINS A1=FE_OFN2_bus_we_d1 A2=bus_waddr_d1<7> Z=n_22
+ VSS=DVSS VDD=DVDD
Xp11422A3263__6417 CKAN2D0 $PINS A1=bus_wbuf<1> A2=FE_OFN2_bus_we_d1 Z=n_21
+ VSS=DVSS VDD=DVDD
Xp11774A3264__5477 CKAN2D0 $PINS A1=FE_OFN2_bus_we_d1 A2=bus_waddr_d1<8> Z=n_20
+ VSS=DVSS VDD=DVDD
Xp11774A3265__2398 CKAN2D0 $PINS A1=FE_OFN2_bus_we_d1 A2=bus_waddr_d1<4> Z=n_19
+ VSS=DVSS VDD=DVDD
Xp11422A3266__5107 CKAN2D0 $PINS A1=bus_wbuf<57> A2=FE_OFN2_bus_we_d1 Z=n_18
+ VSS=DVSS VDD=DVDD
Xp11774A3267__6260 CKAN2D0 $PINS A1=FE_OFN2_bus_we_d1 A2=bus_waddr_d1<5> Z=n_17
+ VSS=DVSS VDD=DVDD
Xp11774A3268__4319 CKAN2D0 $PINS A1=FE_OFN2_bus_we_d1 A2=bus_waddr_d1<0> Z=n_16
+ VSS=DVSS VDD=DVDD
Xp11774A3269__8428 CKAN2D0 $PINS A1=FE_OFN2_bus_we_d1 A2=bus_waddr_d1<3> Z=n_15
+ VSS=DVSS VDD=DVDD
Xp11422A3270__5526 CKAN2D0 $PINS A1=bus_wbuf<33> A2=FE_OFN2_bus_we_d1 Z=n_14
+ VSS=DVSS VDD=DVDD
XFp23701A CKND0 $PINS I=FE_PHN189_n_91 ZN=n_13 VSS=DVSS VDD=DVDD
Xp23616A__6783 IND2D1 $PINS A1=n_89 B1=FE_PHN12_bus_addr_1 ZN=n_91 VSS=DVSS
+ VDD=DVDD
Xp23543A__3680 IND2D0 $PINS A1=n_90 B1=bus_addr<2> ZN=n_89 VSS=DVSS VDD=DVDD
Xp11189A__1617 OR2D0 $PINS A1=sram_cen_ff A2=FE_OFN1_tpu_re Z=sram_wen VSS=DVSS
+ VDD=DVDD
Xp11168A__2802 INR2D0 $PINS A1=sram_cen_ff B1=FE_OFN1_tpu_re ZN=sram_cen
+ VSS=DVSS VDD=DVDD
Xp23533A__1705 CKND2D0 $PINS A1=FE_PHN14_bus_we A2=FE_PHN13_bus_addr_0 ZN=n_90
+ VSS=DVSS VDD=DVDD
Xbus_wbuf_reg[0] DFXQD1 $PINS CP=CTS_6 DA=FE_PHN343_bus_wbuf_0
+ DB=FE_PHN508_bus_din_0 Q=bus_wbuf<0> SA=n_11 VSS=DVSS VDD=DVDD
Xbus_wbuf_reg[1] DFXQD1 $PINS CP=CTS_6 DA=FE_PHN44_bus_wbuf_1
+ DB=FE_PHN438_bus_din_1 Q=bus_wbuf<1> SA=n_11 VSS=DVSS VDD=DVDD
Xbus_wbuf_reg[2] DFXQD1 $PINS CP=CTS_5 DA=FE_PHN43_bus_wbuf_2
+ DB=FE_PHN173_bus_din_2 Q=bus_wbuf<2> SA=n_11 VSS=DVSS VDD=DVDD
Xbus_wbuf_reg[3] DFXQD1 $PINS CP=CTS_5 DA=FE_PHN41_bus_wbuf_3
+ DB=FE_PHN437_bus_din_3 Q=bus_wbuf<3> SA=n_11 VSS=DVSS VDD=DVDD
Xbus_wbuf_reg[4] DFXQD1 $PINS CP=CTS_5 DA=FE_PHN42_bus_wbuf_4
+ DB=FE_PHN176_bus_din_4 Q=bus_wbuf<4> SA=n_11 VSS=DVSS VDD=DVDD
Xbus_wbuf_reg[5] DFXQD1 $PINS CP=CTS_5 DA=FE_PHN37_bus_wbuf_5
+ DB=FE_PHN521_bus_din_5 Q=bus_wbuf<5> SA=n_11 VSS=DVSS VDD=DVDD
Xbus_wbuf_reg[6] DFXQD1 $PINS CP=CTS_5 DA=FE_PHN40_bus_wbuf_6
+ DB=FE_PHN457_bus_din_6 Q=bus_wbuf<6> SA=n_11 VSS=DVSS VDD=DVDD
Xbus_wbuf_reg[7] DFXQD1 $PINS CP=CTS_5 DA=FE_PHN39_bus_wbuf_7
+ DB=FE_PHN179_bus_din_7 Q=bus_wbuf<7> SA=n_11 VSS=DVSS VDD=DVDD
Xbus_wbuf_reg[8] DFXQD1 $PINS CP=CTS_5 DA=FE_PHN38_bus_wbuf_8
+ DB=FE_PHN505_bus_din_0 Q=bus_wbuf<8> SA=n_5 VSS=DVSS VDD=DVDD
Xbus_wbuf_reg[9] DFXQD1 $PINS CP=CTS_5 DA=FE_PHN35_bus_wbuf_9
+ DB=FE_PHN458_bus_din_1 Q=bus_wbuf<9> SA=n_5 VSS=DVSS VDD=DVDD
Xbus_wbuf_reg[10] DFXQD1 $PINS CP=CTS_5 DA=FE_PHN32_bus_wbuf_10
+ DB=FE_PHN450_bus_din_2 Q=bus_wbuf<10> SA=n_5 VSS=DVSS VDD=DVDD
Xbus_wbuf_reg[11] DFXQD1 $PINS CP=CTS_5 DA=FE_PHN36_bus_wbuf_11
+ DB=FE_PHN437_bus_din_3 Q=bus_wbuf<11> SA=n_5 VSS=DVSS VDD=DVDD
Xbus_wbuf_reg[12] DFXQD1 $PINS CP=CTS_5 DA=FE_PHN31_bus_wbuf_12
+ DB=FE_PHN176_bus_din_4 Q=bus_wbuf<12> SA=n_5 VSS=DVSS VDD=DVDD
Xbus_wbuf_reg[13] DFXQD1 $PINS CP=CTS_5 DA=FE_PHN33_bus_wbuf_13
+ DB=FE_PHN521_bus_din_5 Q=bus_wbuf<13> SA=n_5 VSS=DVSS VDD=DVDD
Xbus_wbuf_reg[14] DFXQD1 $PINS CP=CTS_4 DA=FE_PHN30_bus_wbuf_14
+ DB=FE_PHN457_bus_din_6 Q=bus_wbuf<14> SA=n_5 VSS=DVSS VDD=DVDD
Xbus_wbuf_reg[15] DFXQD1 $PINS CP=CTS_4 DA=FE_PHN34_bus_wbuf_15
+ DB=FE_PHN179_bus_din_7 Q=bus_wbuf<15> SA=n_5 VSS=DVSS VDD=DVDD
Xbus_wbuf_reg[16] DFXQD1 $PINS CP=CTS_4 DA=FE_PHN199_bus_wbuf_16
+ DB=FE_PHN505_bus_din_0 Q=bus_wbuf<16> SA=n_9 VSS=DVSS VDD=DVDD
Xbus_wbuf_reg[17] DFXQD1 $PINS CP=CTS_4 DA=FE_PHN204_bus_wbuf_17
+ DB=FE_PHN458_bus_din_1 Q=bus_wbuf<17> SA=n_9 VSS=DVSS VDD=DVDD
Xbus_wbuf_reg[18] DFXQD1 $PINS CP=CTS_4 DA=FE_PHN205_bus_wbuf_18
+ DB=FE_PHN450_bus_din_2 Q=bus_wbuf<18> SA=n_9 VSS=DVSS VDD=DVDD
Xbus_wbuf_reg[19] DFXQD1 $PINS CP=CTS_4 DA=FE_PHN193_bus_wbuf_19
+ DB=FE_PHN526_bus_din_3 Q=bus_wbuf<19> SA=n_9 VSS=DVSS VDD=DVDD
Xbus_wbuf_reg[20] DFXQD1 $PINS CP=CTS_4 DA=FE_PHN200_bus_wbuf_20
+ DB=FE_PHN176_bus_din_4 Q=bus_wbuf<20> SA=n_9 VSS=DVSS VDD=DVDD
Xbus_wbuf_reg[21] DFXQD1 $PINS CP=CTS_4 DA=FE_PHN201_bus_wbuf_21
+ DB=FE_PHN538_bus_din_5 Q=bus_wbuf<21> SA=n_9 VSS=DVSS VDD=DVDD
Xbus_wbuf_reg[22] DFXQD1 $PINS CP=CTS_4 DA=FE_PHN202_bus_wbuf_22
+ DB=FE_PHN496_bus_din_6 Q=bus_wbuf<22> SA=n_9 VSS=DVSS VDD=DVDD
Xbus_wbuf_reg[23] DFXQD1 $PINS CP=CTS_4 DA=FE_PHN196_bus_wbuf_23
+ DB=FE_PHN179_bus_din_7 Q=bus_wbuf<23> SA=n_9 VSS=DVSS VDD=DVDD
Xbus_wbuf_reg[24] DFXQD1 $PINS CP=CTS_4 DA=FE_PHN190_bus_wbuf_24
+ DB=FE_PHN505_bus_din_0 Q=bus_wbuf<24> SA=n_7 VSS=DVSS VDD=DVDD
Xbus_wbuf_reg[25] DFXQD1 $PINS CP=CTS_9 DA=FE_PHN197_bus_wbuf_25
+ DB=FE_PHN458_bus_din_1 Q=bus_wbuf<25> SA=n_7 VSS=DVSS VDD=DVDD
Xbus_wbuf_reg[26] DFXQD1 $PINS CP=CTS_9 DA=FE_PHN198_bus_wbuf_26
+ DB=FE_PHN450_bus_din_2 Q=bus_wbuf<26> SA=n_7 VSS=DVSS VDD=DVDD
Xbus_wbuf_reg[27] DFXQD1 $PINS CP=CTS_9 DA=FE_PHN203_bus_wbuf_27
+ DB=FE_PHN428_bus_din_3 Q=bus_wbuf<27> SA=n_7 VSS=DVSS VDD=DVDD
Xbus_wbuf_reg[28] DFXQD1 $PINS CP=CTS_9 DA=FE_PHN194_bus_wbuf_28
+ DB=FE_PHN427_bus_din_4 Q=bus_wbuf<28> SA=n_7 VSS=DVSS VDD=DVDD
Xbus_wbuf_reg[29] DFXQD1 $PINS CP=CTS_9 DA=FE_PHN195_bus_wbuf_29
+ DB=FE_PHN524_bus_din_5 Q=bus_wbuf<29> SA=n_7 VSS=DVSS VDD=DVDD
Xbus_wbuf_reg[30] DFXQD1 $PINS CP=CTS_9 DA=FE_PHN191_bus_wbuf_30
+ DB=FE_PHN444_bus_din_6 Q=bus_wbuf<30> SA=n_7 VSS=DVSS VDD=DVDD
Xbus_wbuf_reg[31] DFXQD1 $PINS CP=CTS_9 DA=FE_PHN192_bus_wbuf_31
+ DB=FE_PHN426_bus_din_7 Q=bus_wbuf<31> SA=n_7 VSS=DVSS VDD=DVDD
Xbus_wbuf_reg[32] DFXQD1 $PINS CP=CTS_9 DA=FE_PHN505_bus_din_0
+ DB=FE_PHN217_bus_wbuf_32 Q=bus_wbuf<32> SA=FE_PHN185_n_12 VSS=DVSS VDD=DVDD
Xbus_wbuf_reg[33] DFXQD1 $PINS CP=CTS_3 DA=FE_PHN458_bus_din_1
+ DB=FE_PHN207_bus_wbuf_33 Q=bus_wbuf<33> SA=FE_PHN185_n_12 VSS=DVSS VDD=DVDD
Xbus_wbuf_reg[34] DFXQD1 $PINS CP=CTS_3 DA=FE_PHN450_bus_din_2
+ DB=FE_PHN208_bus_wbuf_34 Q=bus_wbuf<34> SA=FE_PHN185_n_12 VSS=DVSS VDD=DVDD
Xbus_wbuf_reg[35] DFXQD1 $PINS CP=CTS_3 DA=FE_PHN441_bus_din_3
+ DB=FE_PHN209_bus_wbuf_35 Q=bus_wbuf<35> SA=FE_PHN185_n_12 VSS=DVSS VDD=DVDD
Xbus_wbuf_reg[36] DFXQD1 $PINS CP=CTS_2 DA=FE_PHN440_bus_din_4
+ DB=FE_PHN210_bus_wbuf_36 Q=bus_wbuf<36> SA=FE_PHN185_n_12 VSS=DVSS VDD=DVDD
Xbus_wbuf_reg[37] DFXQD1 $PINS CP=CTS_2 DA=FE_PHN525_bus_din_5
+ DB=FE_PHN213_bus_wbuf_37 Q=bus_wbuf<37> SA=FE_PHN185_n_12 VSS=DVSS VDD=DVDD
Xbus_wbuf_reg[38] DFXQD1 $PINS CP=CTS_2 DA=FE_PHN444_bus_din_6
+ DB=FE_PHN214_bus_wbuf_38 Q=bus_wbuf<38> SA=FE_PHN185_n_12 VSS=DVSS VDD=DVDD
Xbus_wbuf_reg[39] DFXQD1 $PINS CP=CTS_2 DA=FE_PHN426_bus_din_7
+ DB=FE_PHN211_bus_wbuf_39 Q=bus_wbuf<39> SA=FE_PHN185_n_12 VSS=DVSS VDD=DVDD
Xbus_wbuf_reg[40] DFXQD1 $PINS CP=CTS_2 DA=FE_PHN505_bus_din_0
+ DB=FE_PHN212_bus_wbuf_40 Q=bus_wbuf<40> SA=FE_PHN188_n_4 VSS=DVSS VDD=DVDD
Xbus_wbuf_reg[41] DFXQD1 $PINS CP=CTS_2 DA=FE_PHN458_bus_din_1
+ DB=FE_PHN219_bus_wbuf_41 Q=bus_wbuf<41> SA=FE_PHN188_n_4 VSS=DVSS VDD=DVDD
Xbus_wbuf_reg[42] DFXQD1 $PINS CP=CTS_2 DA=FE_PHN450_bus_din_2
+ DB=FE_PHN215_bus_wbuf_42 Q=bus_wbuf<42> SA=FE_PHN188_n_4 VSS=DVSS VDD=DVDD
Xbus_wbuf_reg[43] DFXQD1 $PINS CP=CTS_2 DA=FE_PHN441_bus_din_3
+ DB=FE_PHN220_bus_wbuf_43 Q=bus_wbuf<43> SA=FE_PHN188_n_4 VSS=DVSS VDD=DVDD
Xbus_wbuf_reg[44] DFXQD1 $PINS CP=CTS_2 DA=FE_PHN440_bus_din_4
+ DB=FE_PHN216_bus_wbuf_44 Q=bus_wbuf<44> SA=FE_PHN188_n_4 VSS=DVSS VDD=DVDD
Xbus_wbuf_reg[45] DFXQD1 $PINS CP=CTS_2 DA=FE_PHN522_bus_din_5
+ DB=FE_PHN218_bus_wbuf_45 Q=bus_wbuf<45> SA=FE_PHN188_n_4 VSS=DVSS VDD=DVDD
Xbus_wbuf_reg[46] DFXQD1 $PINS CP=CTS_1 DA=FE_PHN444_bus_din_6
+ DB=FE_PHN221_bus_wbuf_46 Q=bus_wbuf<46> SA=FE_PHN188_n_4 VSS=DVSS VDD=DVDD
Xbus_wbuf_reg[47] DFXQD1 $PINS CP=CTS_1 DA=FE_PHN426_bus_din_7
+ DB=FE_PHN222_bus_wbuf_47 Q=bus_wbuf<47> SA=FE_PHN188_n_4 VSS=DVSS VDD=DVDD
Xbus_wbuf_reg[48] DFXQD1 $PINS CP=CTS_1 DA=FE_PHN505_bus_din_0
+ DB=FE_PHN22_bus_wbuf_48 Q=bus_wbuf<48> SA=FE_PHN186_n_10 VSS=DVSS VDD=DVDD
Xbus_wbuf_reg[49] DFXQD1 $PINS CP=CTS_1 DA=FE_PHN458_bus_din_1
+ DB=FE_PHN23_bus_wbuf_49 Q=bus_wbuf<49> SA=FE_PHN186_n_10 VSS=DVSS VDD=DVDD
Xbus_wbuf_reg[50] DFXQD1 $PINS CP=CTS_1 DA=FE_PHN450_bus_din_2
+ DB=FE_PHN27_bus_wbuf_50 Q=bus_wbuf<50> SA=FE_PHN186_n_10 VSS=DVSS VDD=DVDD
Xbus_wbuf_reg[51] DFXQD1 $PINS CP=CTS_1 DA=FE_PHN441_bus_din_3
+ DB=FE_PHN25_bus_wbuf_51 Q=bus_wbuf<51> SA=FE_PHN186_n_10 VSS=DVSS VDD=DVDD
Xbus_wbuf_reg[52] DFXQD1 $PINS CP=CTS_1 DA=FE_PHN440_bus_din_4
+ DB=FE_PHN24_bus_wbuf_52 Q=bus_wbuf<52> SA=FE_PHN186_n_10 VSS=DVSS VDD=DVDD
Xbus_wbuf_reg[53] DFXQD1 $PINS CP=CTS_1 DA=FE_PHN522_bus_din_5
+ DB=FE_PHN28_bus_wbuf_53 Q=bus_wbuf<53> SA=FE_PHN186_n_10 VSS=DVSS VDD=DVDD
Xbus_wbuf_reg[54] DFXQD1 $PINS CP=CTS_10 DA=FE_PHN444_bus_din_6
+ DB=FE_PHN29_bus_wbuf_54 Q=bus_wbuf<54> SA=FE_PHN186_n_10 VSS=DVSS VDD=DVDD
Xbus_wbuf_reg[55] DFXQD1 $PINS CP=CTS_10 DA=FE_PHN426_bus_din_7
+ DB=FE_PHN26_bus_wbuf_55 Q=bus_wbuf<55> SA=FE_PHN186_n_10 VSS=DVSS VDD=DVDD
Xbus_wbuf_reg[56] DFXQD1 $PINS CP=CTS_1 DA=FE_PHN224_bus_wbuf_56
+ DB=FE_PHN505_bus_din_0 Q=bus_wbuf<56> SA=FE_PHN189_n_91 VSS=DVSS VDD=DVDD
Xbus_wbuf_reg[57] DFXQD1 $PINS CP=CTS_1 DA=FE_PHN230_bus_wbuf_57
+ DB=FE_PHN458_bus_din_1 Q=bus_wbuf<57> SA=FE_PHN189_n_91 VSS=DVSS VDD=DVDD
Xbus_wbuf_reg[58] DFXQD1 $PINS CP=CTS_1 DA=FE_PHN229_bus_wbuf_58
+ DB=FE_PHN450_bus_din_2 Q=bus_wbuf<58> SA=FE_PHN189_n_91 VSS=DVSS VDD=DVDD
Xbus_wbuf_reg[59] DFXQD1 $PINS CP=CTS_1 DA=FE_PHN228_bus_wbuf_59
+ DB=FE_PHN441_bus_din_3 Q=bus_wbuf<59> SA=FE_PHN189_n_91 VSS=DVSS VDD=DVDD
Xbus_wbuf_reg[60] DFXQD1 $PINS CP=CTS_1 DA=FE_PHN226_bus_wbuf_60
+ DB=FE_PHN440_bus_din_4 Q=bus_wbuf<60> SA=FE_PHN189_n_91 VSS=DVSS VDD=DVDD
Xbus_wbuf_reg[61] DFXQD1 $PINS CP=CTS_10 DA=FE_PHN227_bus_wbuf_61
+ DB=FE_PHN522_bus_din_5 Q=bus_wbuf<61> SA=FE_PHN189_n_91 VSS=DVSS VDD=DVDD
Xbus_wbuf_reg[62] DFXQD1 $PINS CP=CTS_10 DA=FE_PHN223_bus_wbuf_62
+ DB=FE_PHN444_bus_din_6 Q=bus_wbuf<62> SA=FE_PHN189_n_91 VSS=DVSS VDD=DVDD
Xbus_wbuf_reg[63] DFXQD1 $PINS CP=CTS_10 DA=FE_PHN225_bus_wbuf_63
+ DB=FE_PHN426_bus_din_7 Q=bus_wbuf<63> SA=FE_PHN189_n_91 VSS=DVSS VDD=DVDD
Xsram_cen_ff_reg DFNSND1 $PINS CPN=CTS_9 D=n_1 Q=sram_cen_ff QN=UNCONNECTED72
+ SDN=rstn VSS=DVSS VDD=DVDD
Xp23572A__5122 NR2D1 $PINS A1=FE_PHN307_n_8 A2=FE_PHN12_bus_addr_1 ZN=n_12
+ VSS=DVSS VDD=DVDD
Xp23649A__8246 ND2D1 $PINS A1=FE_PHN184_n_6 A2=n_0 ZN=n_11 VSS=DVSS VDD=DVDD
Xp23572A3363__7098 NR2D2 $PINS A1=n_8 A2=n_0 ZN=n_10 VSS=DVSS VDD=DVDD
Xp23649A3364__6131 CKND2D0 $PINS A1=FE_PHN184_n_6 A2=FE_PHN235_bus_addr_1
+ ZN=n_9 VSS=DVSS VDD=DVDD
Xp23566A__1881 CKND2D0 $PINS A1=n_2 A2=FE_PHN413_bus_addr_2 ZN=n_8 VSS=DVSS
+ VDD=DVDD
Xp23658A__5115 ND2D0 $PINS A1=FE_PHN181_n_3 A2=FE_PHN235_bus_addr_1 ZN=n_7
+ VSS=DVSS VDD=DVDD
Xp23607A__7482 INR2D0 $PINS A1=n_2 B1=bus_addr<2> ZN=n_6 VSS=DVSS VDD=DVDD
Xp23658A3365__4733 CKND2D0 $PINS A1=FE_PHN181_n_3 A2=n_0 ZN=n_5 VSS=DVSS
+ VDD=DVDD
Xp23566A3367__6161 NR2XD0 $PINS A1=n_89 A2=FE_PHN12_bus_addr_1 ZN=n_4 VSS=DVSS
+ VDD=DVDD
Xp23639A__9315 NR2D0 $PINS A1=n_90 A2=FE_PHN514_bus_addr_2 ZN=n_3 VSS=DVSS
+ VDD=DVDD
Xp23529A__9945 INR2D0 $PINS A1=FE_PHN14_bus_we B1=FE_PHN13_bus_addr_0 ZN=n_2
+ VSS=DVSS VDD=DVDD
XFp23597A CKND0 $PINS I=FE_PHN235_bus_addr_1 ZN=n_0 VSS=DVSS VDD=DVDD
Xbus_we_d1_reg DFCND1 $PINS CDN=FE_PHN21_rstn CP=CTS_9 D=n_13 Q=bus_we_d1
+ QN=n_1 VSS=DVSS VDD=DVDD
XFILLER_T_5_118 DCAP8 $PINS VSS=DVSS VDD=DVDD
XFILLER_T_5_117 DCAP64 $PINS VSS=DVSS VDD=DVDD
XFILLER_T_5_115 DCAP8 $PINS VSS=DVSS VDD=DVDD
XFILLER_T_5_112 DCAP4 $PINS VSS=DVSS VDD=DVDD
XFILLER_T_5_111 DCAP8 $PINS VSS=DVSS VDD=DVDD
XFILLER_T_5_110 DCAP32 $PINS VSS=DVSS VDD=DVDD
XFILLER_T_5_107 DCAP8 $PINS VSS=DVSS VDD=DVDD
XFILLER_T_5_106 DCAP4 $PINS VSS=DVSS VDD=DVDD
XFILLER_T_4_151 DCAP4 $PINS VSS=DVSS VDD=DVDD
XFILLER_T_5_100 DCAP4 $PINS VSS=DVSS VDD=DVDD
XFILLER_T_5_88 DCAP8 $PINS VSS=DVSS VDD=DVDD
XFILLER_T_5_86 DCAP4 $PINS VSS=DVSS VDD=DVDD
XFILLER_T_5_85 DCAP8 $PINS VSS=DVSS VDD=DVDD
XFILLER_T_5_83 DCAP8 $PINS VSS=DVSS VDD=DVDD
XFILLER_T_4_134 DCAP4 $PINS VSS=DVSS VDD=DVDD
XFILLER_T_4_133 DCAP8 $PINS VSS=DVSS VDD=DVDD
XFILLER_T_4_127 DCAP4 $PINS VSS=DVSS VDD=DVDD
XFILLER_T_5_74 DCAP8 $PINS VSS=DVSS VDD=DVDD
XFILLER_T_4_118 DCAP8 $PINS VSS=DVSS VDD=DVDD
XFILLER_T_4_117 DCAP8 $PINS VSS=DVSS VDD=DVDD
XFILLER_T_4_114 DCAP4 $PINS VSS=DVSS VDD=DVDD
XFILLER_T_4_110 DCAP4 $PINS VSS=DVSS VDD=DVDD
XFILLER_T_4_108 DCAP4 $PINS VSS=DVSS VDD=DVDD
XFILLER_T_4_106 DCAP4 $PINS VSS=DVSS VDD=DVDD
XFILLER_T_5_65 DCAP16 $PINS VSS=DVSS VDD=DVDD
XFILLER_T_4_104 DCAP4 $PINS VSS=DVSS VDD=DVDD
XFILLER_T_4_99 DCAP4 $PINS VSS=DVSS VDD=DVDD
XFILLER_T_5_60 DCAP4 $PINS VSS=DVSS VDD=DVDD
XFILLER_T_4_97 DCAP4 $PINS VSS=DVSS VDD=DVDD
XFILLER_T_5_59 DCAP8 $PINS VSS=DVSS VDD=DVDD
XFILLER_T_4_91 DCAP4 $PINS VSS=DVSS VDD=DVDD
XFILLER_T_5_53 DCAP4 $PINS VSS=DVSS VDD=DVDD
XFILLER_T_4_85 DCAP4 $PINS VSS=DVSS VDD=DVDD
XFILLER_T_5_50 DCAP8 $PINS VSS=DVSS VDD=DVDD
XFILLER_T_4_81 DCAP8 $PINS VSS=DVSS VDD=DVDD
XFILLER_T_4_76 DCAP8 $PINS VSS=DVSS VDD=DVDD
XFILLER_T_4_74 DCAP8 $PINS VSS=DVSS VDD=DVDD
XFILLER_T_5_30 DCAP4 $PINS VSS=DVSS VDD=DVDD
XFILLER_T_5_26 DCAP4 $PINS VSS=DVSS VDD=DVDD
XFILLER_T_5_19 DCAP8 $PINS VSS=DVSS VDD=DVDD
XFILLER_T_5_17 DCAP4 $PINS VSS=DVSS VDD=DVDD
XFILLER_T_2_251 DCAP4 $PINS VSS=DVSS VDD=DVDD
XFILLER_T_2_247 DCAP8 $PINS VSS=DVSS VDD=DVDD
XFILLER_T_2_239 DCAP8 $PINS VSS=DVSS VDD=DVDD
XFILLER_T_2_232 DCAP4 $PINS VSS=DVSS VDD=DVDD
XFILLER_T_2_225 DCAP4 $PINS VSS=DVSS VDD=DVDD
XFILLER_T_2_219 DCAP4 $PINS VSS=DVSS VDD=DVDD
XFILLER_T_2_216 DCAP4 $PINS VSS=DVSS VDD=DVDD
XFILLER_T_2_213 DCAP8 $PINS VSS=DVSS VDD=DVDD
XFILLER_T_2_208 DCAP4 $PINS VSS=DVSS VDD=DVDD
XFILLER_T_2_205 DCAP4 $PINS VSS=DVSS VDD=DVDD
XFILLER_T_2_204 DCAP8 $PINS VSS=DVSS VDD=DVDD
XFILLER_T_2_201 DCAP4 $PINS VSS=DVSS VDD=DVDD
XFILLER_T_2_197 DCAP8 $PINS VSS=DVSS VDD=DVDD
XFILLER_T_2_195 DCAP4 $PINS VSS=DVSS VDD=DVDD
XFILLER_T_2_194 DCAP8 $PINS VSS=DVSS VDD=DVDD
XFILLER_T_2_191 DCAP8 $PINS VSS=DVSS VDD=DVDD
XFILLER_T_2_179 DCAP8 $PINS VSS=DVSS VDD=DVDD
XFILLER_T_2_178 DCAP8 $PINS VSS=DVSS VDD=DVDD
XFILLER_T_2_170 DCAP4 $PINS VSS=DVSS VDD=DVDD
XFILLER_T_2_167 DCAP4 $PINS VSS=DVSS VDD=DVDD
XFILLER_T_2_166 DCAP8 $PINS VSS=DVSS VDD=DVDD
XFILLER_T_2_160 DCAP8 $PINS VSS=DVSS VDD=DVDD
XFILLER_T_2_156 DCAP4 $PINS VSS=DVSS VDD=DVDD
XFILLER_T_2_155 DCAP8 $PINS VSS=DVSS VDD=DVDD
XFILLER_T_2_152 DCAP8 $PINS VSS=DVSS VDD=DVDD
XFILLER_T_2_150 DCAP4 $PINS VSS=DVSS VDD=DVDD
XFILLER_T_2_149 DCAP4 $PINS VSS=DVSS VDD=DVDD
XFILLER_T_2_148 DCAP8 $PINS VSS=DVSS VDD=DVDD
XFILLER_T_2_146 DCAP8 $PINS VSS=DVSS VDD=DVDD
XFILLER_T_2_143 DCAP4 $PINS VSS=DVSS VDD=DVDD
XFILLER_T_2_142 DCAP8 $PINS VSS=DVSS VDD=DVDD
XFILLER_T_2_139 DCAP8 $PINS VSS=DVSS VDD=DVDD
XFILLER_T_2_137 DCAP8 $PINS VSS=DVSS VDD=DVDD
XFILLER_T_2_135 DCAP4 $PINS VSS=DVSS VDD=DVDD
XFILLER_T_2_134 DCAP8 $PINS VSS=DVSS VDD=DVDD
XFILLER_T_2_132 DCAP4 $PINS VSS=DVSS VDD=DVDD
XFILLER_T_2_131 DCAP4 $PINS VSS=DVSS VDD=DVDD
XFILLER_T_2_130 DCAP8 $PINS VSS=DVSS VDD=DVDD
XFILLER_T_2_127 DCAP8 $PINS VSS=DVSS VDD=DVDD
XFILLER_T_2_125 DCAP4 $PINS VSS=DVSS VDD=DVDD
XFILLER_T_2_119 DCAP4 $PINS VSS=DVSS VDD=DVDD
XFILLER_T_2_118 DCAP8 $PINS VSS=DVSS VDD=DVDD
XFILLER_T_1_126 DCAP4 $PINS VSS=DVSS VDD=DVDD
XFILLER_T_2_116 DCAP8 $PINS VSS=DVSS VDD=DVDD
XFILLER_T_2_113 DCAP8 $PINS VSS=DVSS VDD=DVDD
XFILLER_T_1_120 DCAP4 $PINS VSS=DVSS VDD=DVDD
XFILLER_T_2_111 DCAP8 $PINS VSS=DVSS VDD=DVDD
XFILLER_T_2_109 DCAP4 $PINS VSS=DVSS VDD=DVDD
XFILLER_T_1_117 DCAP4 $PINS VSS=DVSS VDD=DVDD
XFILLER_T_1_115 DCAP4 $PINS VSS=DVSS VDD=DVDD
XFILLER_T_2_107 DCAP8 $PINS VSS=DVSS VDD=DVDD
XFILLER_T_1_114 DCAP4 $PINS VSS=DVSS VDD=DVDD
XFILLER_T_1_113 DCAP4 $PINS VSS=DVSS VDD=DVDD
XFILLER_T_2_100 DCAP8 $PINS VSS=DVSS VDD=DVDD
XFILLER_T_1_106 DCAP4 $PINS VSS=DVSS VDD=DVDD
XFILLER_T_1_103 DCAP4 $PINS VSS=DVSS VDD=DVDD
XFILLER_T_1_100 DCAP4 $PINS VSS=DVSS VDD=DVDD
XFILLER_T_2_89 DCAP4 $PINS VSS=DVSS VDD=DVDD
XFILLER_T_2_88 DCAP8 $PINS VSS=DVSS VDD=DVDD
XFILLER_T_2_86 DCAP8 $PINS VSS=DVSS VDD=DVDD
XFILLER_T_2_75 DCAP4 $PINS VSS=DVSS VDD=DVDD
XFILLER_T_2_71 DCAP8 $PINS VSS=DVSS VDD=DVDD
XFILLER_T_2_68 DCAP4 $PINS VSS=DVSS VDD=DVDD
XFILLER_T_2_67 DCAP8 $PINS VSS=DVSS VDD=DVDD
XFILLER_T_2_64 DCAP8 $PINS VSS=DVSS VDD=DVDD
XFILLER_T_2_54 DCAP4 $PINS VSS=DVSS VDD=DVDD
XFILLER_T_2_53 DCAP8 $PINS VSS=DVSS VDD=DVDD
XFILLER_T_2_51 DCAP8 $PINS VSS=DVSS VDD=DVDD
XFILLER_T_2_48 DCAP8 $PINS VSS=DVSS VDD=DVDD
XFILLER_T_2_43 DCAP4 $PINS VSS=DVSS VDD=DVDD
XFILLER_T_2_42 DCAP8 $PINS VSS=DVSS VDD=DVDD
XFILLER_T_2_36 DCAP8 $PINS VSS=DVSS VDD=DVDD
XFILLER_T_2_33 DCAP8 $PINS VSS=DVSS VDD=DVDD
XFILLER_T_2_29 DCAP8 $PINS VSS=DVSS VDD=DVDD
XFILLER_T_2_19 DCAP8 $PINS VSS=DVSS VDD=DVDD
XFILLER_T_2_12 DCAP8 $PINS VSS=DVSS VDD=DVDD
XFILLER_T_2_6 DCAP8 $PINS VSS=DVSS VDD=DVDD
XFILLER_T_2_2 DCAP8 $PINS VSS=DVSS VDD=DVDD
.ENDS
.GLOBAL DVDD
.GLOBAL DVSS
